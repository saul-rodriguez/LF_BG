ADE simulation setup
Run mode: Single Run, Sweeps and Corners
Tests:
  BANDGAP:BG_0_8_V2:1: BANDGAP/BG_0_8_V3/schematic, simulator spectre
    Outputs: dB20(VF("/VREF"))
  MC (off): BANDGAP/BG_0_8_V3/schematic, simulator spectre
    Outputs: histogram2D(value(VS("/VREF") 50) 5 "standard" "both" nil)
Corners (all switched off):
  model folders: /opt/pdk/lf11/PDK_LF11ISi_V1_3_2/analog/models/spectre
  every corner: /opt/pdk/lf11/PDK_LF11ISi_V1_3_2/analog/models/spectre/lf11is.scs[1v2hvt_ss 1v2hvt_ff 1v2hvt_fs 1v2hvt_sf, 3v3rvt_tt, dio_typ, mim_typ, cvnm2m3_typ, cvnm2m4_typ, nvar1v2hvt_typ, nvar3v3rvt_typ]
  MOS_BJT_RES: lf11is.scs[res_max res_min, bjt_fast bjt_slow]
  MOS (off): lf11is.scs[res_typ, bjt_typ]
  MOS_BJT (off): lf11is.scs[res_typ, bjt_fast bjt_slow]
