ADE simulation setup
Run mode: Monte Carlo Sampling
Tests:
  BANDGAP:REF_TB:1: BANDGAP/REF_TB/schematic, simulator spectre
    Outputs: V1000; V550; I4X; I1X
Global variables:
  CL2 = 3p
  VREF_PULSE = 10m
  CL = 150f
  IBIAS = 200n
  UNIT_RES = 20k
  VDD = 1.2
  VDD_PULSE = 0
  PD = 1.2
  PD_PULSE = 0
Corners:
  model folders: /opt/pdk/lf11/PDK_LF11ISi_V1_3_2/analog/models/spectre
  C0 (off): temperature=-40 85; VDD=1.08 1.32; lf11is.scs[1v2hvt_ff 1v2hvt_fs 1v2hvt_sf 1v2hvt_ss, res_max res_min, mim_max mim_min, cvnm2m3_typ, cvnm2m4_typ, dio_typ, bjt_typ, nvar1v2hvt_typ, 3v3rvt_tt, nvar3v3rvt_typ]
  MOS_RES_CAP_TEMP (off): temperature=-40 85; lf11is.scs[1v2hvt_ff 1v2hvt_fs 1v2hvt_sf 1v2hvt_ss, res_max res_min, mim_max mim_min, cvnm2m3_typ, cvnm2m4_typ, dio_typ, bjt_typ, nvar1v2hvt_typ, 3v3rvt_tt, nvar3v3rvt_typ]
Monte Carlo Sampling options: mcmethod=all, mcnumpoints=200, parasiticanalysis=0
