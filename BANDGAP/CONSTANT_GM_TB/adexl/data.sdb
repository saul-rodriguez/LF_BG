ADE simulation setup
Run mode: Single Run, Sweeps and Corners
Tests:
  BANDGAP:CONSTANT_GM_TB:1: BANDGAP/CONSTANT_GM_TB/schematic, simulator spectre
    Outputs: i("/R0/PLUS" ?result "dcOp")
  START_UP (off): BANDGAP/CONSTANT_GM_TB/schematic, simulator spectre
Global variables (all switched off):
  VDD = 1.2 (off)
  VDD_PULSE = 1.2 (off)
Corners:
  model folders: /opt/pdk/lf11/PDK_LF11ISi_V1_3_2/analog/models/spectre
  MOS_RES (off): temperature=-40 85; lf11is.scs[1v2hvt_ff 1v2hvt_fs 1v2hvt_sf 1v2hvt_ss, res_max res_min]
  RES (off): lf11is.scs[1v2hvt_tt, res_max res_min]
  MOS (off): lf11is.scs[1v2hvt_ff 1v2hvt_fs 1v2hvt_sf 1v2hvt_ss, res_typ]
