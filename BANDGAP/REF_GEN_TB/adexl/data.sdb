ADE simulation setup
Run mode: Monte Carlo Sampling
Tests:
  OP (off): BANDGAP/REF_GEN_TB/schematic, simulator spectre
    Outputs: V1000; V550; I32nA; I128nA; BangapRef
  TRAN: BANDGAP/REF_GEN_TB/schematic, simulator spectre
    Outputs: V1000; V550; I32nA; I128nA; BangapRef; /EN; /VDD; /I8/I0/PRN_TRIGGER; /I8/I0/PRN; /PRN
Global variables:
  CL = 150f
  CL2 = 3p
  CONF_BG_SL_TRIM = 3
  CONF_BG_TRIM = 3
  CONF_REF_TRIM = 3
  CONF_LVDS_SEL = 0
  PD = 1.2
  PD_PULSE = 1.2
  VDD = 0 (off)
  VDD_PULSE = 0 (off)
  EN = 1.2 (off)
  EN_PULSE = 0 (off)
  CONF_LDO_SEL = 0
  TT = 1u (off)
Corners:
  model folders: /opt/pdk/lf11/PDK_LF11ISi_V1_3_2/analog/models/spectre
  every corner: /opt/pdk/lf11/PDK_LF11ISi_V1_3_2/analog/models/spectre/lf11is.scs[1v2hvt_ss 1v2hvt_ff 1v2hvt_fs 1v2hvt_sf, 3v3rvt_tt, dio_typ, mim_typ, cvnm2m3_typ, cvnm2m4_typ, nvar1v2hvt_typ, nvar3v3rvt_typ]
  MOS_BJT_RES (off): lf11is.scs[res_max res_min, bjt_fast bjt_slow]
  MOS_BJT_RES_TEMP (off): temperature=-40 85; lf11is.scs[res_max res_min, bjt_fast bjt_slow]
  MOS_RES_TEMP (off): temperature=-40 85; lf11is.scs[res_max res_min, bjt_typ]
  MOS_BJT_RES_VDD (off): VDD=1.08 1.32; lf11is.scs[res_max res_min, bjt_fast bjt_slow]
  MOS (off): lf11is.scs[res_typ, bjt_typ]
  MOS_BJT (off): lf11is.scs[res_typ, bjt_fast bjt_slow]
Monte Carlo Sampling options: mcmethod=all, mcnumpoints=200, parasiticanalysis=0
