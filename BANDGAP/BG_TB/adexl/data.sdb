ADE simulation setup
Run mode: Monte Carlo Sampling
Tests:
  BANDGAP:BG_TB:1 (off): BANDGAP/BG_TB/schematic, simulator spectre
  Op: BANDGAP/BG_TB/schematic, simulator spectre
    Outputs: VDC("/I0/STARTUP_REF"); VDC("/VREF"); /I0/STARTUP_REF; /VDD; /PD
  Trans (off): BANDGAP/BG_TB/schematic, simulator spectre
    Outputs: VDC("/I0/STARTUP_REF"); VDC("/VREF"); /I0/STARTUP_REF; /VDD; /PD; /BIAS
Global variables:
  VDD = 1.2
  VDD_PULSE = 0
  PD = 1.2
  PD_PULSE = 0
Corners:
  model folders: /opt/pdk/lf11/PDK_LF11ISi_V1_3_2/analog/models/spectre
  every corner: /opt/pdk/lf11/PDK_LF11ISi_V1_3_2/analog/models/spectre/lf11is.scs[1v2hvt_ss 1v2hvt_ff 1v2hvt_fs 1v2hvt_sf, 3v3rvt_tt, dio_typ, mim_typ, cvnm2m3_typ, cvnm2m4_typ, nvar1v2hvt_typ, nvar3v3rvt_typ]
  MOS_BJT_RES (off): lf11is.scs[res_max res_min, bjt_fast bjt_slow]
  MOS_BJT_RES_TEMP (off): temperature=-40 85; lf11is.scs[res_max res_min, bjt_fast bjt_slow]
  MOS_BJT_RES_VDD (off): VDD=1.08 1.32; lf11is.scs[res_max res_min, bjt_fast bjt_slow]
  MOS (off): lf11is.scs[res_typ, bjt_typ]
  MOS_BJT (off): lf11is.scs[res_typ, bjt_fast bjt_slow]
Monte Carlo Sampling options: ignoremode=default, mcmethod=all, mcnumpoints=200, parasiticanalysis=0
