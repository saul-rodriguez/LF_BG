* +++++++++++++++++++++++++++++++++++++++++++++++++++++++++ *
* CDL Netlist:                                              *
*                                                           *
* Cell Name  : REF_V5_fL                                    *
* Netlisted  : Mon Jul  6 11:32:59 2026                     *
* PVS Version: 24.11-s045 Mon Jan 27 22:18:54 PST 2025      *
* +++++++++++++++++++++++++++++++++++++++++++++++++++++++++ *
*.LDD
*.DEVTMPLT 0 C(cmims2) CMIMS2 TOPMIMS2(POS) METAL5a(NEG)
*.DEVTMPLT 1 MN(nmos1v2hvt) NMOS1V2HVT NDIFF(D) NGATE(G) NDIFF(S) PW1V2(B)
*.DEVTMPLT 2 MP(pmos1v2hvt) PMOS1V2HVT PDIFF(D) PGATE(G) PDIFF(S) NW1V2(B)
*.DEVTMPLT 3 R(rnpolym) RNPOLYMNW1V2 POLYG3(POS) POLYG3(NEG) NW1V2(SUB)

* +++++++++++++++++++++++++++++++++++++++++++++++++++++++++ *
* Sub cell: M1_M2_CDNS_783337574920                         *
* +++++++++++++++++++++++++++++++++++++++++++++++++++++++++ *
.subckt M1_M2_CDNS_783337574920 1
** N=1 EP=1 FDC=0
.ends M1_M2_CDNS_783337574920

* +++++++++++++++++++++++++++++++++++++++++++++++++++++++++ *
* Sub cell: M1_M2_CDNS_783337574922                         *
* +++++++++++++++++++++++++++++++++++++++++++++++++++++++++ *
.subckt M1_M2_CDNS_783337574922 1
** N=1 EP=1 FDC=0
.ends M1_M2_CDNS_783337574922

* +++++++++++++++++++++++++++++++++++++++++++++++++++++++++ *
* Sub cell: M1_M2_CDNS_783337574923                         *
* +++++++++++++++++++++++++++++++++++++++++++++++++++++++++ *
.subckt M1_M2_CDNS_783337574923 1
** N=1 EP=1 FDC=0
.ends M1_M2_CDNS_783337574923

* +++++++++++++++++++++++++++++++++++++++++++++++++++++++++ *
* Sub cell: PG_M1_CDNS_783337574924                         *
* +++++++++++++++++++++++++++++++++++++++++++++++++++++++++ *
.subckt PG_M1_CDNS_783337574924 1
** N=1 EP=1 FDC=0
.ends PG_M1_CDNS_783337574924

* +++++++++++++++++++++++++++++++++++++++++++++++++++++++++ *
* Sub cell: M1_M2_CDNS_783337574925                         *
* +++++++++++++++++++++++++++++++++++++++++++++++++++++++++ *
.subckt M1_M2_CDNS_783337574925 1
** N=1 EP=1 FDC=0
.ends M1_M2_CDNS_783337574925

* +++++++++++++++++++++++++++++++++++++++++++++++++++++++++ *
* Sub cell: M1_M2_CDNS_783337574926                         *
* +++++++++++++++++++++++++++++++++++++++++++++++++++++++++ *
.subckt M1_M2_CDNS_783337574926 1
** N=1 EP=1 FDC=0
.ends M1_M2_CDNS_783337574926

* +++++++++++++++++++++++++++++++++++++++++++++++++++++++++ *
* Sub cell: M2_M3_CDNS_783337574928                         *
* +++++++++++++++++++++++++++++++++++++++++++++++++++++++++ *
.subckt M2_M3_CDNS_783337574928 1
** N=1 EP=1 FDC=0
.ends M2_M3_CDNS_783337574928

* +++++++++++++++++++++++++++++++++++++++++++++++++++++++++ *
* Sub cell: M1_M2_CDNS_783337574929                         *
* +++++++++++++++++++++++++++++++++++++++++++++++++++++++++ *
.subckt M1_M2_CDNS_783337574929 1
** N=1 EP=1 FDC=0
.ends M1_M2_CDNS_783337574929

* +++++++++++++++++++++++++++++++++++++++++++++++++++++++++ *
* Sub cell: M4_M5_CDNS_7833375749217                        *
* +++++++++++++++++++++++++++++++++++++++++++++++++++++++++ *
.subckt M4_M5_CDNS_7833375749217 1
** N=1 EP=1 FDC=0
.ends M4_M5_CDNS_7833375749217

* +++++++++++++++++++++++++++++++++++++++++++++++++++++++++ *
* Sub cell: M3_M4_CDNS_7833375749218                        *
* +++++++++++++++++++++++++++++++++++++++++++++++++++++++++ *
.subckt M3_M4_CDNS_7833375749218 1
** N=1 EP=1 FDC=0
.ends M3_M4_CDNS_7833375749218

* +++++++++++++++++++++++++++++++++++++++++++++++++++++++++ *
* Sub cell: M2_M3_CDNS_7833375749219                        *
* +++++++++++++++++++++++++++++++++++++++++++++++++++++++++ *
.subckt M2_M3_CDNS_7833375749219 1
** N=1 EP=1 FDC=0
.ends M2_M3_CDNS_7833375749219

* +++++++++++++++++++++++++++++++++++++++++++++++++++++++++ *
* Sub cell: M1_M2_CDNS_7833375749220                        *
* +++++++++++++++++++++++++++++++++++++++++++++++++++++++++ *
.subckt M1_M2_CDNS_7833375749220 1
** N=1 EP=1 FDC=0
.ends M1_M2_CDNS_7833375749220

* +++++++++++++++++++++++++++++++++++++++++++++++++++++++++ *
* Sub cell: Contact_CDNS_783337574921                       *
* +++++++++++++++++++++++++++++++++++++++++++++++++++++++++ *
.subckt Contact_CDNS_783337574921 1 2
** N=2 EP=2 FDC=0
.ends Contact_CDNS_783337574921

* +++++++++++++++++++++++++++++++++++++++++++++++++++++++++ *
* Sub cell: Contact_CDNS_783337574922                       *
* +++++++++++++++++++++++++++++++++++++++++++++++++++++++++ *
.subckt Contact_CDNS_783337574922 1
** N=1 EP=1 FDC=0
.ends Contact_CDNS_783337574922

* +++++++++++++++++++++++++++++++++++++++++++++++++++++++++ *
* Sub cell: Contact_CDNS_783337574923                       *
* +++++++++++++++++++++++++++++++++++++++++++++++++++++++++ *
.subckt Contact_CDNS_783337574923 1
** N=1 EP=1 FDC=0
.ends Contact_CDNS_783337574923

* +++++++++++++++++++++++++++++++++++++++++++++++++++++++++ *
* Sub cell: AbutContact_CDNS_783337574924                   *
* +++++++++++++++++++++++++++++++++++++++++++++++++++++++++ *
.subckt AbutContact_CDNS_783337574924 1 2
** N=2 EP=2 FDC=0
.ends AbutContact_CDNS_783337574924

* +++++++++++++++++++++++++++++++++++++++++++++++++++++++++ *
* Sub cell: pmos1v2hvt_4_CDNS_783337574920                  *
* +++++++++++++++++++++++++++++++++++++++++++++++++++++++++ *
.subckt pmos1v2hvt_4_CDNS_783337574920 1 2 3 4 5
** N=5 EP=5 FDC=1
X0 2 5 Contact_CDNS_783337574921 $T=-245 130 0 0 $X=-245 $Y=0
X1 3 5 Contact_CDNS_783337574921 $T=2095 130 0 0 $X=2095 $Y=0
X2 2 Contact_CDNS_783337574922 $T=-275 140 0 0 $X=-275 $Y=0
X3 3 Contact_CDNS_783337574922 $T=2065 140 0 0 $X=2065 $Y=0
X4 1 Contact_CDNS_783337574923 $T=120 10140 0 0 $X=0 $Y=10140
X5 4 5 AbutContact_CDNS_783337574924 $T=-430 -560 0 0 $X=-520 $Y=-620
M0 3 1 2 4 pmos1v2hvt L=2e-06 W=1e-05 AD=3e-12 AS=3e-12 PD=1.06e-05 PS=1.06e-05 m=1 $X=0 $Y=0 $dt=2
.ends pmos1v2hvt_4_CDNS_783337574920

* +++++++++++++++++++++++++++++++++++++++++++++++++++++++++ *
* Sub cell: AbutContact_CDNS_783337574927                   *
* +++++++++++++++++++++++++++++++++++++++++++++++++++++++++ *
.subckt AbutContact_CDNS_783337574927 1
** N=1 EP=1 FDC=0
.ends AbutContact_CDNS_783337574927

* +++++++++++++++++++++++++++++++++++++++++++++++++++++++++ *
* Sub cell: pmos1v2hvt_4_CDNS_783337574925                  *
* +++++++++++++++++++++++++++++++++++++++++++++++++++++++++ *
.subckt pmos1v2hvt_4_CDNS_783337574925 1 2 3
** N=3 EP=3 FDC=1
X0 2 3 Contact_CDNS_783337574921 $T=-245 130 0 0 $X=-245 $Y=0
X1 1 3 Contact_CDNS_783337574921 $T=595 130 0 0 $X=595 $Y=0
X2 2 AbutContact_CDNS_783337574927 $T=-430 -560 0 0 $X=-520 $Y=-620
M0 1 1 2 2 pmos1v2hvt L=5e-07 W=1e-05 AD=3e-12 AS=3e-12 PD=1.06e-05 PS=1.06e-05 m=1 $X=0 $Y=0 $dt=2
.ends pmos1v2hvt_4_CDNS_783337574925

* +++++++++++++++++++++++++++++++++++++++++++++++++++++++++ *
* Sub cell: Contact_CDNS_7833375749210                      *
* +++++++++++++++++++++++++++++++++++++++++++++++++++++++++ *
.subckt Contact_CDNS_7833375749210 1
** N=1 EP=1 FDC=0
.ends Contact_CDNS_7833375749210

* +++++++++++++++++++++++++++++++++++++++++++++++++++++++++ *
* Sub cell: nmos1v2hvt_4_CDNS_783337574928                  *
* +++++++++++++++++++++++++++++++++++++++++++++++++++++++++ *
.subckt nmos1v2hvt_4_CDNS_783337574928 1 2 3 4
** N=4 EP=4 FDC=1
X0 2 Contact_CDNS_7833375749210 $T=-245 130 0 0 $X=-245 $Y=0
X1 4 Contact_CDNS_7833375749210 $T=595 130 0 0 $X=595 $Y=0
M0 4 1 2 3 nmos1v2hvt L=5e-07 W=1e-06 AD=3e-13 AS=3e-13 PD=1.6e-06 PS=1.6e-06 m=1 $X=0 $Y=0 $dt=1
.ends nmos1v2hvt_4_CDNS_783337574928

* +++++++++++++++++++++++++++++++++++++++++++++++++++++++++ *
* Sub cell: Contact_CDNS_7833375749212                      *
* +++++++++++++++++++++++++++++++++++++++++++++++++++++++++ *
.subckt Contact_CDNS_7833375749212 1
** N=1 EP=1 FDC=0
.ends Contact_CDNS_7833375749212

* +++++++++++++++++++++++++++++++++++++++++++++++++++++++++ *
* Sub cell: pmos1v2hvt_4_CDNS_7833375749211                 *
* +++++++++++++++++++++++++++++++++++++++++++++++++++++++++ *
.subckt pmos1v2hvt_4_CDNS_7833375749211 1 2 3 4
** N=4 EP=4 FDC=1
X0 2 AbutContact_CDNS_783337574927 $T=-430 -560 0 0 $X=-520 $Y=-620
X1 2 Contact_CDNS_7833375749212 $T=-245 180 0 0 $X=-245 $Y=55
X2 3 Contact_CDNS_7833375749212 $T=595 180 0 0 $X=595 $Y=55
M0 3 1 2 2 pmos1v2hvt L=5e-07 W=2e-06 AD=6e-13 AS=6e-13 PD=2.6e-06 PS=2.6e-06 m=1 $X=0 $Y=0 $dt=2
.ends pmos1v2hvt_4_CDNS_7833375749211

* +++++++++++++++++++++++++++++++++++++++++++++++++++++++++ *
* Sub cell: Contact_CDNS_7833375749214                      *
* +++++++++++++++++++++++++++++++++++++++++++++++++++++++++ *
.subckt Contact_CDNS_7833375749214 1
** N=1 EP=1 FDC=0
.ends Contact_CDNS_7833375749214

* +++++++++++++++++++++++++++++++++++++++++++++++++++++++++ *
* Sub cell: rnpolym_CDNS_7833375749213                      *
* +++++++++++++++++++++++++++++++++++++++++++++++++++++++++ *
.subckt rnpolym_CDNS_7833375749213 1 2 3
** N=4 EP=3 FDC=2
X0 2 Contact_CDNS_7833375749214 $T=-30 -520 0 0 $X=-50 $Y=-540
X1 4 Contact_CDNS_7833375749214 $T=-30 35260 0 0 $X=-50 $Y=35240
X2 1 Contact_CDNS_7833375749214 $T=720 -520 0 0 $X=700 $Y=-540
X3 4 Contact_CDNS_7833375749214 $T=720 35260 0 0 $X=700 $Y=35240
R0 2 4 16727.1 L=3.5e-05 W=5e-07 $[rnpolym] $SUB=3 $X=0 $Y=0 $dt=3
R1 1 4 16727.1 L=3.5e-05 W=5e-07 $[rnpolym] $SUB=3 $X=750 $Y=0 $dt=3
.ends rnpolym_CDNS_7833375749213

* +++++++++++++++++++++++++++++++++++++++++++++++++++++++++ *
* Sub cell: rnpolym_CDNS_7833375749215                      *
* +++++++++++++++++++++++++++++++++++++++++++++++++++++++++ *
.subckt rnpolym_CDNS_7833375749215 1 2
** N=23 EP=2 FDC=22
X0 1 Contact_CDNS_7833375749214 $T=-30 -520 0 0 $X=-50 $Y=-540
X1 3 Contact_CDNS_7833375749214 $T=-30 35260 0 0 $X=-50 $Y=35240
X2 4 Contact_CDNS_7833375749214 $T=720 -520 0 0 $X=700 $Y=-540
X3 3 Contact_CDNS_7833375749214 $T=720 35260 0 0 $X=700 $Y=35240
X4 4 Contact_CDNS_7833375749214 $T=1470 -520 0 0 $X=1450 $Y=-540
X5 5 Contact_CDNS_7833375749214 $T=1470 35260 0 0 $X=1450 $Y=35240
X6 6 Contact_CDNS_7833375749214 $T=2220 -520 0 0 $X=2200 $Y=-540
X7 5 Contact_CDNS_7833375749214 $T=2220 35260 0 0 $X=2200 $Y=35240
X8 6 Contact_CDNS_7833375749214 $T=2970 -520 0 0 $X=2950 $Y=-540
X9 7 Contact_CDNS_7833375749214 $T=2970 35260 0 0 $X=2950 $Y=35240
X10 8 Contact_CDNS_7833375749214 $T=3720 -520 0 0 $X=3700 $Y=-540
X11 7 Contact_CDNS_7833375749214 $T=3720 35260 0 0 $X=3700 $Y=35240
X12 8 Contact_CDNS_7833375749214 $T=4470 -520 0 0 $X=4450 $Y=-540
X13 9 Contact_CDNS_7833375749214 $T=4470 35260 0 0 $X=4450 $Y=35240
X14 10 Contact_CDNS_7833375749214 $T=5220 -520 0 0 $X=5200 $Y=-540
X15 9 Contact_CDNS_7833375749214 $T=5220 35260 0 0 $X=5200 $Y=35240
X16 10 Contact_CDNS_7833375749214 $T=5970 -520 0 0 $X=5950 $Y=-540
X17 11 Contact_CDNS_7833375749214 $T=5970 35260 0 0 $X=5950 $Y=35240
X18 12 Contact_CDNS_7833375749214 $T=6720 -520 0 0 $X=6700 $Y=-540
X19 11 Contact_CDNS_7833375749214 $T=6720 35260 0 0 $X=6700 $Y=35240
X20 12 Contact_CDNS_7833375749214 $T=7470 -520 0 0 $X=7450 $Y=-540
X21 13 Contact_CDNS_7833375749214 $T=7470 35260 0 0 $X=7450 $Y=35240
X22 14 Contact_CDNS_7833375749214 $T=8220 -520 0 0 $X=8200 $Y=-540
X23 13 Contact_CDNS_7833375749214 $T=8220 35260 0 0 $X=8200 $Y=35240
X24 14 Contact_CDNS_7833375749214 $T=8970 -520 0 0 $X=8950 $Y=-540
X25 15 Contact_CDNS_7833375749214 $T=8970 35260 0 0 $X=8950 $Y=35240
X26 16 Contact_CDNS_7833375749214 $T=9720 -520 0 0 $X=9700 $Y=-540
X27 15 Contact_CDNS_7833375749214 $T=9720 35260 0 0 $X=9700 $Y=35240
X28 16 Contact_CDNS_7833375749214 $T=10470 -520 0 0 $X=10450 $Y=-540
X29 17 Contact_CDNS_7833375749214 $T=10470 35260 0 0 $X=10450 $Y=35240
X30 18 Contact_CDNS_7833375749214 $T=11220 -520 0 0 $X=11200 $Y=-540
X31 17 Contact_CDNS_7833375749214 $T=11220 35260 0 0 $X=11200 $Y=35240
X32 18 Contact_CDNS_7833375749214 $T=11970 -520 0 0 $X=11950 $Y=-540
X33 19 Contact_CDNS_7833375749214 $T=11970 35260 0 0 $X=11950 $Y=35240
X34 20 Contact_CDNS_7833375749214 $T=12720 -520 0 0 $X=12700 $Y=-540
X35 19 Contact_CDNS_7833375749214 $T=12720 35260 0 0 $X=12700 $Y=35240
X36 20 Contact_CDNS_7833375749214 $T=13470 -520 0 0 $X=13450 $Y=-540
X37 21 Contact_CDNS_7833375749214 $T=13470 35260 0 0 $X=13450 $Y=35240
X38 22 Contact_CDNS_7833375749214 $T=14220 -520 0 0 $X=14200 $Y=-540
X39 21 Contact_CDNS_7833375749214 $T=14220 35260 0 0 $X=14200 $Y=35240
X40 22 Contact_CDNS_7833375749214 $T=14970 -520 0 0 $X=14950 $Y=-540
X41 23 Contact_CDNS_7833375749214 $T=14970 35260 0 0 $X=14950 $Y=35240
X42 2 Contact_CDNS_7833375749214 $T=15720 -520 0 0 $X=15700 $Y=-540
X43 23 Contact_CDNS_7833375749214 $T=15720 35260 0 0 $X=15700 $Y=35240
R0 1 3 16727.1 L=3.5e-05 W=5e-07 $[rnpolym] $SUB=2 $X=0 $Y=0 $dt=3
R1 4 3 16727.1 L=3.5e-05 W=5e-07 $[rnpolym] $SUB=2 $X=750 $Y=0 $dt=3
R2 4 5 16727.1 L=3.5e-05 W=5e-07 $[rnpolym] $SUB=2 $X=1500 $Y=0 $dt=3
R3 6 5 16727.1 L=3.5e-05 W=5e-07 $[rnpolym] $SUB=2 $X=2250 $Y=0 $dt=3
R4 6 7 16727.1 L=3.5e-05 W=5e-07 $[rnpolym] $SUB=2 $X=3000 $Y=0 $dt=3
R5 8 7 16727.1 L=3.5e-05 W=5e-07 $[rnpolym] $SUB=2 $X=3750 $Y=0 $dt=3
R6 8 9 16727.1 L=3.5e-05 W=5e-07 $[rnpolym] $SUB=2 $X=4500 $Y=0 $dt=3
R7 10 9 16727.1 L=3.5e-05 W=5e-07 $[rnpolym] $SUB=2 $X=5250 $Y=0 $dt=3
R8 10 11 16727.1 L=3.5e-05 W=5e-07 $[rnpolym] $SUB=2 $X=6000 $Y=0 $dt=3
R9 12 11 16727.1 L=3.5e-05 W=5e-07 $[rnpolym] $SUB=2 $X=6750 $Y=0 $dt=3
R10 12 13 16727.1 L=3.5e-05 W=5e-07 $[rnpolym] $SUB=2 $X=7500 $Y=0 $dt=3
R11 14 13 16727.1 L=3.5e-05 W=5e-07 $[rnpolym] $SUB=2 $X=8250 $Y=0 $dt=3
R12 14 15 16727.1 L=3.5e-05 W=5e-07 $[rnpolym] $SUB=2 $X=9000 $Y=0 $dt=3
R13 16 15 16727.1 L=3.5e-05 W=5e-07 $[rnpolym] $SUB=2 $X=9750 $Y=0 $dt=3
R14 16 17 16727.1 L=3.5e-05 W=5e-07 $[rnpolym] $SUB=2 $X=10500 $Y=0 $dt=3
R15 18 17 16727.1 L=3.5e-05 W=5e-07 $[rnpolym] $SUB=2 $X=11250 $Y=0 $dt=3
R16 18 19 16727.1 L=3.5e-05 W=5e-07 $[rnpolym] $SUB=2 $X=12000 $Y=0 $dt=3
R17 20 19 16727.1 L=3.5e-05 W=5e-07 $[rnpolym] $SUB=2 $X=12750 $Y=0 $dt=3
R18 20 21 16727.1 L=3.5e-05 W=5e-07 $[rnpolym] $SUB=2 $X=13500 $Y=0 $dt=3
R19 22 21 16727.1 L=3.5e-05 W=5e-07 $[rnpolym] $SUB=2 $X=14250 $Y=0 $dt=3
R20 22 23 16727.1 L=3.5e-05 W=5e-07 $[rnpolym] $SUB=2 $X=15000 $Y=0 $dt=3
R21 2 23 16727.1 L=3.5e-05 W=5e-07 $[rnpolym] $SUB=2 $X=15750 $Y=0 $dt=3
.ends rnpolym_CDNS_7833375749215

* +++++++++++++++++++++++++++++++++++++++++++++++++++++++++ *
* Sub cell: rnpolym_CDNS_7833375749216                      *
* +++++++++++++++++++++++++++++++++++++++++++++++++++++++++ *
.subckt rnpolym_CDNS_7833375749216 1 2 3
** N=3 EP=3 FDC=1
X0 1 Contact_CDNS_7833375749214 $T=-30 -520 0 0 $X=-50 $Y=-540
X1 2 Contact_CDNS_7833375749214 $T=-30 35260 0 0 $X=-50 $Y=35240
R0 1 2 16727.1 L=3.5e-05 W=5e-07 $[rnpolym] $SUB=3 $X=0 $Y=0 $dt=3
.ends rnpolym_CDNS_7833375749216

* +++++++++++++++++++++++++++++++++++++++++++++++++++++++++ *
* Sub cell: rnpolym_CDNS_7833375749217                      *
* +++++++++++++++++++++++++++++++++++++++++++++++++++++++++ *
.subckt rnpolym_CDNS_7833375749217 1 2 3
** N=6 EP=3 FDC=4
X0 2 Contact_CDNS_7833375749214 $T=-30 -520 0 0 $X=-50 $Y=-540
X1 4 Contact_CDNS_7833375749214 $T=-30 35260 0 0 $X=-50 $Y=35240
X2 5 Contact_CDNS_7833375749214 $T=720 -520 0 0 $X=700 $Y=-540
X3 4 Contact_CDNS_7833375749214 $T=720 35260 0 0 $X=700 $Y=35240
X4 5 Contact_CDNS_7833375749214 $T=1470 -520 0 0 $X=1450 $Y=-540
X5 6 Contact_CDNS_7833375749214 $T=1470 35260 0 0 $X=1450 $Y=35240
X6 1 Contact_CDNS_7833375749214 $T=2220 -520 0 0 $X=2200 $Y=-540
X7 6 Contact_CDNS_7833375749214 $T=2220 35260 0 0 $X=2200 $Y=35240
R0 2 4 16727.1 L=3.5e-05 W=5e-07 $[rnpolym] $SUB=3 $X=0 $Y=0 $dt=3
R1 5 4 16727.1 L=3.5e-05 W=5e-07 $[rnpolym] $SUB=3 $X=750 $Y=0 $dt=3
R2 5 6 16727.1 L=3.5e-05 W=5e-07 $[rnpolym] $SUB=3 $X=1500 $Y=0 $dt=3
R3 1 6 16727.1 L=3.5e-05 W=5e-07 $[rnpolym] $SUB=3 $X=2250 $Y=0 $dt=3
.ends rnpolym_CDNS_7833375749217

* +++++++++++++++++++++++++++++++++++++++++++++++++++++++++ *
* Sub cell: rnpolym_CDNS_7833375749218                      *
* +++++++++++++++++++++++++++++++++++++++++++++++++++++++++ *
.subckt rnpolym_CDNS_7833375749218 1 2 3
** N=3 EP=3 FDC=1
X0 1 Contact_CDNS_7833375749214 $T=-30 -520 0 0 $X=-50 $Y=-540
X1 2 Contact_CDNS_7833375749214 $T=-30 35260 0 0 $X=-50 $Y=35240
R0 1 2 16727.1 L=3.5e-05 W=5e-07 $[rnpolym] $SUB=3 $X=0 $Y=0 $dt=3
.ends rnpolym_CDNS_7833375749218

* +++++++++++++++++++++++++++++++++++++++++++++++++++++++++ *
* Sub cell: Contact_CDNS_7833375749220                      *
* +++++++++++++++++++++++++++++++++++++++++++++++++++++++++ *
.subckt Contact_CDNS_7833375749220 1
** N=1 EP=1 FDC=0
.ends Contact_CDNS_7833375749220

* +++++++++++++++++++++++++++++++++++++++++++++++++++++++++ *
* Sub cell: AbutContact_CDNS_7833375749221                  *
* +++++++++++++++++++++++++++++++++++++++++++++++++++++++++ *
.subckt AbutContact_CDNS_7833375749221 1
** N=1 EP=1 FDC=0
.ends AbutContact_CDNS_7833375749221

* +++++++++++++++++++++++++++++++++++++++++++++++++++++++++ *
* Sub cell: pmos1v2hvt_4_CDNS_7833375749219                 *
* +++++++++++++++++++++++++++++++++++++++++++++++++++++++++ *
.subckt pmos1v2hvt_4_CDNS_7833375749219 1 2 3 4 5
** N=5 EP=5 FDC=1
X0 2 5 Contact_CDNS_783337574921 $T=-245 130 0 0 $X=-245 $Y=0
X1 3 5 Contact_CDNS_783337574921 $T=1095 130 0 0 $X=1095 $Y=0
X2 2 Contact_CDNS_783337574922 $T=-275 140 0 0 $X=-275 $Y=0
X3 3 Contact_CDNS_783337574922 $T=1065 140 0 0 $X=1065 $Y=0
X4 1 Contact_CDNS_7833375749220 $T=70 10140 0 0 $X=0 $Y=10140
X5 4 AbutContact_CDNS_7833375749221 $T=-330 -560 0 0 $X=-520 $Y=-620
M0 3 1 2 4 pmos1v2hvt L=1e-06 W=1e-05 AD=3e-12 AS=3e-12 PD=1.06e-05 PS=1.06e-05 m=1 $X=0 $Y=0 $dt=2
.ends pmos1v2hvt_4_CDNS_7833375749219

* +++++++++++++++++++++++++++++++++++++++++++++++++++++++++ *
* Sub cell: mux8_1p_fL                                      *
* +++++++++++++++++++++++++++++++++++++++++++++++++++++++++ *
.subckt mux8_1p_fL 1 2 3 4 5 6 7 8 9 10
+ 11 12 13 14 15 16 17 18 19
** N=19 EP=19 FDC=8
X0 1 5 8 2 19 pmos1v2hvt_4_CDNS_7833375749219 $T=825 940 0 0 $X=205 $Y=220
X1 3 6 8 2 19 pmos1v2hvt_4_CDNS_7833375749219 $T=3065 940 0 0 $X=2445 $Y=220
X2 4 7 8 2 19 pmos1v2hvt_4_CDNS_7833375749219 $T=5305 940 0 0 $X=4685 $Y=220
X3 9 12 8 2 19 pmos1v2hvt_4_CDNS_7833375749219 $T=7545 940 0 0 $X=6925 $Y=220
X4 10 13 8 2 19 pmos1v2hvt_4_CDNS_7833375749219 $T=9785 940 0 0 $X=9165 $Y=220
X5 11 14 8 2 19 pmos1v2hvt_4_CDNS_7833375749219 $T=12025 940 0 0 $X=11405 $Y=220
X6 15 17 8 2 19 pmos1v2hvt_4_CDNS_7833375749219 $T=14265 940 0 0 $X=13645 $Y=220
X7 16 18 8 2 19 pmos1v2hvt_4_CDNS_7833375749219 $T=16505 940 0 0 $X=15885 $Y=220
.ends mux8_1p_fL

* +++++++++++++++++++++++++++++++++++++++++++++++++++++++++ *
* Sub cell: trim_res_rnpolyn_2_fL                           *
* +++++++++++++++++++++++++++++++++++++++++++++++++++++++++ *
.subckt trim_res_rnpolyn_2_fL 1 2 3
** N=4 EP=3 FDC=14
X0 1 Contact_CDNS_7833375749214 $T=225 225 0 0 $X=205 $Y=205
X1 2 Contact_CDNS_7833375749214 $T=225 36005 0 0 $X=205 $Y=35985
X2 1 Contact_CDNS_7833375749214 $T=975 225 0 0 $X=955 $Y=205
X3 2 Contact_CDNS_7833375749214 $T=975 36005 0 0 $X=955 $Y=35985
X4 1 Contact_CDNS_7833375749214 $T=1725 225 0 0 $X=1705 $Y=205
X5 2 Contact_CDNS_7833375749214 $T=1725 36005 0 0 $X=1705 $Y=35985
X6 1 Contact_CDNS_7833375749214 $T=2475 225 0 0 $X=2455 $Y=205
X7 2 Contact_CDNS_7833375749214 $T=2475 36005 0 0 $X=2455 $Y=35985
X8 1 Contact_CDNS_7833375749214 $T=3225 225 0 0 $X=3205 $Y=205
X9 2 Contact_CDNS_7833375749214 $T=3225 36005 0 0 $X=3205 $Y=35985
X10 1 Contact_CDNS_7833375749214 $T=3975 225 0 0 $X=3955 $Y=205
X11 2 Contact_CDNS_7833375749214 $T=3975 36005 0 0 $X=3955 $Y=35985
X12 1 Contact_CDNS_7833375749214 $T=4725 225 0 0 $X=4705 $Y=205
X13 2 Contact_CDNS_7833375749214 $T=4725 36005 0 0 $X=4705 $Y=35985
X14 1 Contact_CDNS_7833375749214 $T=5475 225 0 0 $X=5455 $Y=205
X15 2 Contact_CDNS_7833375749214 $T=5475 36005 0 0 $X=5455 $Y=35985
X16 1 Contact_CDNS_7833375749214 $T=6225 225 0 0 $X=6205 $Y=205
X17 2 Contact_CDNS_7833375749214 $T=6225 36005 0 0 $X=6205 $Y=35985
X18 1 Contact_CDNS_7833375749214 $T=6975 225 0 0 $X=6955 $Y=205
X19 2 Contact_CDNS_7833375749214 $T=6975 36005 0 0 $X=6955 $Y=35985
X20 1 Contact_CDNS_7833375749214 $T=7725 225 0 0 $X=7705 $Y=205
X21 2 Contact_CDNS_7833375749214 $T=7725 36005 0 0 $X=7705 $Y=35985
X22 1 Contact_CDNS_7833375749214 $T=8475 225 0 0 $X=8455 $Y=205
X23 2 Contact_CDNS_7833375749214 $T=8475 36005 0 0 $X=8455 $Y=35985
X24 1 4 3 rnpolym_CDNS_7833375749216 $T=9255 745 0 0 $X=9005 $Y=5
X25 4 2 3 rnpolym_CDNS_7833375749216 $T=10005 35745 1 0 $X=9755 $Y=5
R0 1 2 16727.1 L=3.5e-05 W=5e-07 $[rnpolym] $SUB=3 $X=255 $Y=745 $dt=3
R1 1 2 16727.1 L=3.5e-05 W=5e-07 $[rnpolym] $SUB=3 $X=1005 $Y=745 $dt=3
R2 1 2 16727.1 L=3.5e-05 W=5e-07 $[rnpolym] $SUB=3 $X=1755 $Y=745 $dt=3
R3 1 2 16727.1 L=3.5e-05 W=5e-07 $[rnpolym] $SUB=3 $X=2505 $Y=745 $dt=3
R4 1 2 16727.1 L=3.5e-05 W=5e-07 $[rnpolym] $SUB=3 $X=3255 $Y=745 $dt=3
R5 1 2 16727.1 L=3.5e-05 W=5e-07 $[rnpolym] $SUB=3 $X=4005 $Y=745 $dt=3
R6 1 2 16727.1 L=3.5e-05 W=5e-07 $[rnpolym] $SUB=3 $X=4755 $Y=745 $dt=3
R7 1 2 16727.1 L=3.5e-05 W=5e-07 $[rnpolym] $SUB=3 $X=5505 $Y=745 $dt=3
R8 1 2 16727.1 L=3.5e-05 W=5e-07 $[rnpolym] $SUB=3 $X=6255 $Y=745 $dt=3
R9 1 2 16727.1 L=3.5e-05 W=5e-07 $[rnpolym] $SUB=3 $X=7005 $Y=745 $dt=3
R10 1 2 16727.1 L=3.5e-05 W=5e-07 $[rnpolym] $SUB=3 $X=7755 $Y=745 $dt=3
R11 1 2 16727.1 L=3.5e-05 W=5e-07 $[rnpolym] $SUB=3 $X=8505 $Y=745 $dt=3
.ends trim_res_rnpolyn_2_fL

* +++++++++++++++++++++++++++++++++++++++++++++++++++++++++ *
* Sub cell: trim_res_array_rn_2_fL                          *
* +++++++++++++++++++++++++++++++++++++++++++++++++++++++++ *
.subckt trim_res_array_rn_2_fL 1 2 3 4 5 6 7
** N=15 EP=7 FDC=196
X0 8 M1_M2_CDNS_7833375749220 $T=129170 42990 0 0 $X=128365 $Y=42855
X1 8 M1_M2_CDNS_7833375749220 $T=134110 42990 0 0 $X=133305 $Y=42855
X2 3 2 1 trim_res_rnpolyn_2_fL $T=5445 6855 0 0 $X=5450 $Y=6145
X3 2 4 1 trim_res_rnpolyn_2_fL $T=15945 6855 0 0 $X=15950 $Y=6145
X4 4 5 1 trim_res_rnpolyn_2_fL $T=26445 6855 0 0 $X=26450 $Y=6145
X5 5 6 1 trim_res_rnpolyn_2_fL $T=36945 6855 0 0 $X=36950 $Y=6145
X6 6 9 1 trim_res_rnpolyn_2_fL $T=47445 6855 0 0 $X=47450 $Y=6145
X7 9 10 1 trim_res_rnpolyn_2_fL $T=57945 6855 0 0 $X=57950 $Y=6145
X8 10 11 1 trim_res_rnpolyn_2_fL $T=68445 6855 0 0 $X=68450 $Y=6145
X9 11 12 1 trim_res_rnpolyn_2_fL $T=78945 6855 0 0 $X=78950 $Y=6145
X10 12 13 1 trim_res_rnpolyn_2_fL $T=89445 6855 0 0 $X=89450 $Y=6145
X11 13 14 1 trim_res_rnpolyn_2_fL $T=99945 6855 0 0 $X=99950 $Y=6145
X12 14 15 1 trim_res_rnpolyn_2_fL $T=110445 6855 0 0 $X=110450 $Y=6145
X13 15 8 1 trim_res_rnpolyn_2_fL $T=120945 6855 0 0 $X=120950 $Y=6145
X14 7 8 1 trim_res_rnpolyn_2_fL $T=142350 6855 1 180 $X=131595 $Y=6145
X15 7 8 1 trim_res_rnpolyn_2_fL $T=142105 6855 0 0 $X=142110 $Y=6145
.ends trim_res_array_rn_2_fL

* +++++++++++++++++++++++++++++++++++++++++++++++++++++++++ *
* Sub cell: M2_M3_CDNS_7833375749222                        *
* +++++++++++++++++++++++++++++++++++++++++++++++++++++++++ *
.subckt M2_M3_CDNS_7833375749222 1
** N=1 EP=1 FDC=0
.ends M2_M3_CDNS_7833375749222

* +++++++++++++++++++++++++++++++++++++++++++++++++++++++++ *
* Sub cell: nmos1v2hvt_4_CDNS_7833375749223                 *
* +++++++++++++++++++++++++++++++++++++++++++++++++++++++++ *
.subckt nmos1v2hvt_4_CDNS_7833375749223 1 2 3 4
** N=4 EP=4 FDC=1
X0 2 4 Contact_CDNS_783337574921 $T=-245 130 0 0 $X=-245 $Y=0
X1 3 4 Contact_CDNS_783337574921 $T=1095 130 0 0 $X=1095 $Y=0
X2 2 Contact_CDNS_783337574922 $T=-275 140 0 0 $X=-275 $Y=0
X3 3 Contact_CDNS_783337574922 $T=1065 140 0 0 $X=1065 $Y=0
M0 3 1 2 4 nmos1v2hvt L=1e-06 W=1e-05 AD=3e-12 AS=3e-12 PD=1.06e-05 PS=1.06e-05 m=1 $X=0 $Y=0 $dt=1
.ends nmos1v2hvt_4_CDNS_7833375749223

* +++++++++++++++++++++++++++++++++++++++++++++++++++++++++ *
* Sub cell: mux8_1_fL                                       *
* +++++++++++++++++++++++++++++++++++++++++++++++++++++++++ *
.subckt mux8_1_fL 1 2 3 4 5 6 7 8 9 10
+ 11 12 13 14 15 16 17 18
** N=18 EP=18 FDC=8
X0 1 M1_M2_CDNS_783337574922 $T=2015 11725 0 0 $X=1735 $Y=11415
X1 2 M1_M2_CDNS_783337574922 $T=4215 11725 0 0 $X=3935 $Y=11415
X2 7 M1_M2_CDNS_783337574922 $T=6415 11725 0 0 $X=6135 $Y=11415
X3 8 M1_M2_CDNS_783337574922 $T=8615 11725 0 0 $X=8335 $Y=11415
X4 11 M1_M2_CDNS_783337574922 $T=10815 11725 0 0 $X=10535 $Y=11415
X5 12 M1_M2_CDNS_783337574922 $T=13015 11725 0 0 $X=12735 $Y=11415
X6 15 M1_M2_CDNS_783337574922 $T=15215 11725 0 0 $X=14935 $Y=11415
X7 16 M1_M2_CDNS_783337574922 $T=17415 11725 0 0 $X=17135 $Y=11415
X8 1 M2_M3_CDNS_7833375749222 $T=2015 11725 0 0 $X=1685 $Y=11375
X9 2 M2_M3_CDNS_7833375749222 $T=4215 11725 0 0 $X=3885 $Y=11375
X10 7 M2_M3_CDNS_7833375749222 $T=6415 11725 0 0 $X=6085 $Y=11375
X11 8 M2_M3_CDNS_7833375749222 $T=8615 11725 0 0 $X=8285 $Y=11375
X12 11 M2_M3_CDNS_7833375749222 $T=10815 11725 0 0 $X=10485 $Y=11375
X13 12 M2_M3_CDNS_7833375749222 $T=13015 11725 0 0 $X=12685 $Y=11375
X14 15 M2_M3_CDNS_7833375749222 $T=15215 11725 0 0 $X=14885 $Y=11375
X15 16 M2_M3_CDNS_7833375749222 $T=17415 11725 0 0 $X=17085 $Y=11375
X16 1 6 4 3 nmos1v2hvt_4_CDNS_7833375749223 $T=1515 1315 0 0 $X=915 $Y=915
X17 2 6 5 3 nmos1v2hvt_4_CDNS_7833375749223 $T=3715 1315 0 0 $X=3115 $Y=915
X18 7 6 9 3 nmos1v2hvt_4_CDNS_7833375749223 $T=5915 1315 0 0 $X=5315 $Y=915
X19 8 6 10 3 nmos1v2hvt_4_CDNS_7833375749223 $T=8115 1315 0 0 $X=7515 $Y=915
X20 11 6 13 3 nmos1v2hvt_4_CDNS_7833375749223 $T=10315 1315 0 0 $X=9715 $Y=915
X21 12 6 14 3 nmos1v2hvt_4_CDNS_7833375749223 $T=12515 1315 0 0 $X=11915 $Y=915
X22 15 6 17 3 nmos1v2hvt_4_CDNS_7833375749223 $T=14715 1315 0 0 $X=14115 $Y=915
X23 16 6 18 3 nmos1v2hvt_4_CDNS_7833375749223 $T=16915 1315 0 0 $X=16315 $Y=915
.ends mux8_1_fL

* +++++++++++++++++++++++++++++++++++++++++++++++++++++++++ *
* Sub cell: pmos1v2hvt_4_CDNS_7833375749225                 *
* +++++++++++++++++++++++++++++++++++++++++++++++++++++++++ *
.subckt pmos1v2hvt_4_CDNS_7833375749225 1 2 3 4
** N=4 EP=4 FDC=1
X0 2 4 Contact_CDNS_783337574921 $T=-245 130 0 0 $X=-245 $Y=0
X1 1 4 Contact_CDNS_783337574921 $T=1095 130 0 0 $X=1095 $Y=0
X2 1 Contact_CDNS_7833375749220 $T=70 10120 0 0 $X=0 $Y=10120
X3 3 AbutContact_CDNS_7833375749221 $T=-330 -560 0 0 $X=-520 $Y=-620
M0 1 1 2 3 pmos1v2hvt L=1e-06 W=1e-05 AD=3e-12 AS=3e-12 PD=1.06e-05 PS=1.06e-05 m=1 $X=0 $Y=0 $dt=2
.ends pmos1v2hvt_4_CDNS_7833375749225

* +++++++++++++++++++++++++++++++++++++++++++++++++++++++++ *
* Sub cell: IN2                                             *
* +++++++++++++++++++++++++++++++++++++++++++++++++++++++++ *
.subckt IN2 1 2 3 4
** N=4 EP=4 FDC=2
M0 2 1 4 4 nmos1v2hvt L=1.8e-07 W=6e-07 AD=1.8e-13 AS=1.8e-13 PD=1.2e-06 PS=1.2e-06 m=1 $X=375 $Y=390 $dt=1
M1 2 1 3 3 pmos1v2hvt L=1.8e-07 W=9.4e-07 AD=2.82e-13 AS=2.82e-13 PD=1.54e-06 PS=1.54e-06 m=1 $X=375 $Y=1470 $dt=2
.ends IN2

* +++++++++++++++++++++++++++++++++++++++++++++++++++++++++ *
* Sub cell: inv8_fL                                         *
* +++++++++++++++++++++++++++++++++++++++++++++++++++++++++ *
.subckt inv8_fL 1 2 3 4 5 6 7 8 9 10
+ 11 12 13 14 15 16 17 18
** N=18 EP=18 FDC=16
X0 4 1 2 3 IN2 $T=280 335 0 0 $X=55 $Y=85
X1 5 8 2 3 IN2 $T=1480 335 0 0 $X=1255 $Y=85
X2 7 6 2 3 IN2 $T=2680 335 0 0 $X=2455 $Y=85
X3 10 9 2 3 IN2 $T=3880 335 0 0 $X=3655 $Y=85
X4 13 12 2 3 IN2 $T=5080 335 0 0 $X=4855 $Y=85
X5 11 16 2 3 IN2 $T=6280 335 0 0 $X=6055 $Y=85
X6 15 14 2 3 IN2 $T=7480 335 0 0 $X=7255 $Y=85
X7 18 17 2 3 IN2 $T=8680 335 0 0 $X=8455 $Y=85
.ends inv8_fL

* +++++++++++++++++++++++++++++++++++++++++++++++++++++++++ *
* Sub cell: Contact_CDNS_7833375749228                      *
* +++++++++++++++++++++++++++++++++++++++++++++++++++++++++ *
.subckt Contact_CDNS_7833375749228 1 2
** N=2 EP=2 FDC=0
.ends Contact_CDNS_7833375749228

* +++++++++++++++++++++++++++++++++++++++++++++++++++++++++ *
* Sub cell: Contact_CDNS_7833375749229                      *
* +++++++++++++++++++++++++++++++++++++++++++++++++++++++++ *
.subckt Contact_CDNS_7833375749229 1
** N=1 EP=1 FDC=0
.ends Contact_CDNS_7833375749229

* +++++++++++++++++++++++++++++++++++++++++++++++++++++++++ *
* Sub cell: pmos1v2hvt_4_CDNS_7833375749227                 *
* +++++++++++++++++++++++++++++++++++++++++++++++++++++++++ *
.subckt pmos1v2hvt_4_CDNS_7833375749227 1 2 3 4
** N=4 EP=4 FDC=1
X0 2 4 Contact_CDNS_7833375749228 $T=-245 130 0 0 $X=-245 $Y=0
X1 3 4 Contact_CDNS_7833375749228 $T=10095 130 0 0 $X=10095 $Y=0
X2 2 Contact_CDNS_7833375749229 $T=-275 115 0 0 $X=-275 $Y=0
X3 3 Contact_CDNS_7833375749229 $T=10065 115 0 0 $X=10065 $Y=0
M0 3 1 2 2 pmos1v2hvt L=1e-05 W=2.5e-05 AD=7.5e-12 AS=7.5e-12 PD=2.56e-05 PS=2.56e-05 m=1 $X=0 $Y=0 $dt=2
.ends pmos1v2hvt_4_CDNS_7833375749227

* +++++++++++++++++++++++++++++++++++++++++++++++++++++++++ *
* Sub cell: rnpolym_CDNS_7833375749232                      *
* +++++++++++++++++++++++++++++++++++++++++++++++++++++++++ *
.subckt rnpolym_CDNS_7833375749232 1
** N=8 EP=1 FDC=8
X0 1 Contact_CDNS_7833375749214 $T=-30 -520 0 0 $X=-50 $Y=-540
X1 2 Contact_CDNS_7833375749214 $T=-30 35260 0 0 $X=-50 $Y=35240
X2 3 Contact_CDNS_7833375749214 $T=720 -520 0 0 $X=700 $Y=-540
X3 2 Contact_CDNS_7833375749214 $T=720 35260 0 0 $X=700 $Y=35240
X4 3 Contact_CDNS_7833375749214 $T=1470 -520 0 0 $X=1450 $Y=-540
X5 4 Contact_CDNS_7833375749214 $T=1470 35260 0 0 $X=1450 $Y=35240
X6 5 Contact_CDNS_7833375749214 $T=2220 -520 0 0 $X=2200 $Y=-540
X7 4 Contact_CDNS_7833375749214 $T=2220 35260 0 0 $X=2200 $Y=35240
X8 5 Contact_CDNS_7833375749214 $T=2970 -520 0 0 $X=2950 $Y=-540
X9 6 Contact_CDNS_7833375749214 $T=2970 35260 0 0 $X=2950 $Y=35240
X10 7 Contact_CDNS_7833375749214 $T=3720 -520 0 0 $X=3700 $Y=-540
X11 6 Contact_CDNS_7833375749214 $T=3720 35260 0 0 $X=3700 $Y=35240
X12 7 Contact_CDNS_7833375749214 $T=4470 -520 0 0 $X=4450 $Y=-540
X13 8 Contact_CDNS_7833375749214 $T=4470 35260 0 0 $X=4450 $Y=35240
X14 1 Contact_CDNS_7833375749214 $T=5220 -520 0 0 $X=5200 $Y=-540
X15 8 Contact_CDNS_7833375749214 $T=5220 35260 0 0 $X=5200 $Y=35240
R0 1 2 16727.1 L=3.5e-05 W=5e-07 $[rnpolym] $SUB=1 $X=0 $Y=0 $dt=3
R1 3 2 16727.1 L=3.5e-05 W=5e-07 $[rnpolym] $SUB=1 $X=750 $Y=0 $dt=3
R2 3 4 16727.1 L=3.5e-05 W=5e-07 $[rnpolym] $SUB=1 $X=1500 $Y=0 $dt=3
R3 5 4 16727.1 L=3.5e-05 W=5e-07 $[rnpolym] $SUB=1 $X=2250 $Y=0 $dt=3
R4 5 6 16727.1 L=3.5e-05 W=5e-07 $[rnpolym] $SUB=1 $X=3000 $Y=0 $dt=3
R5 7 6 16727.1 L=3.5e-05 W=5e-07 $[rnpolym] $SUB=1 $X=3750 $Y=0 $dt=3
R6 7 8 16727.1 L=3.5e-05 W=5e-07 $[rnpolym] $SUB=1 $X=4500 $Y=0 $dt=3
R7 1 8 16727.1 L=3.5e-05 W=5e-07 $[rnpolym] $SUB=1 $X=5250 $Y=0 $dt=3
.ends rnpolym_CDNS_7833375749232

* +++++++++++++++++++++++++++++++++++++++++++++++++++++++++ *
* Sub cell: Contact_CDNS_7833375749234                      *
* +++++++++++++++++++++++++++++++++++++++++++++++++++++++++ *
.subckt Contact_CDNS_7833375749234 1
** N=1 EP=1 FDC=0
.ends Contact_CDNS_7833375749234

* +++++++++++++++++++++++++++++++++++++++++++++++++++++++++ *
* Sub cell: Contact_CDNS_7833375749236                      *
* +++++++++++++++++++++++++++++++++++++++++++++++++++++++++ *
.subckt Contact_CDNS_7833375749236 1
** N=1 EP=1 FDC=0
.ends Contact_CDNS_7833375749236

* +++++++++++++++++++++++++++++++++++++++++++++++++++++++++ *
* Sub cell: nmos1v2hvt_4_CDNS_7833375749233                 *
* +++++++++++++++++++++++++++++++++++++++++++++++++++++++++ *
.subckt nmos1v2hvt_4_CDNS_7833375749233 1 2 3
** N=3 EP=3 FDC=1
X0 2 Contact_CDNS_7833375749234 $T=-245 180 0 0 $X=-245 $Y=55
X1 3 Contact_CDNS_7833375749234 $T=4095 180 0 0 $X=4095 $Y=55
X2 2 Contact_CDNS_7833375749236 $T=-275 15 0 0 $X=-275 $Y=0
X3 3 Contact_CDNS_7833375749236 $T=4065 15 0 0 $X=4065 $Y=0
M0 3 1 2 2 nmos1v2hvt L=4e-06 W=8e-06 AD=2.4e-12 AS=2.4e-12 PD=8.6e-06 PS=8.6e-06 m=1 $X=0 $Y=0 $dt=1
.ends nmos1v2hvt_4_CDNS_7833375749233

* +++++++++++++++++++++++++++++++++++++++++++++++++++++++++ *
* Sub cell: pmos1v2hvt_4_CDNS_7833375749242                 *
* +++++++++++++++++++++++++++++++++++++++++++++++++++++++++ *
.subckt pmos1v2hvt_4_CDNS_7833375749242 1 2
** N=2 EP=2 FDC=1
X0 1 Contact_CDNS_783337574923 $T=120 25140 0 0 $X=0 $Y=25140
X1 1 2 AbutContact_CDNS_783337574924 $T=-430 -560 0 0 $X=-520 $Y=-620
X2 1 2 Contact_CDNS_7833375749228 $T=-245 130 0 0 $X=-245 $Y=0
X3 1 2 Contact_CDNS_7833375749228 $T=2095 130 0 0 $X=2095 $Y=0
X4 1 Contact_CDNS_7833375749229 $T=-275 115 0 0 $X=-275 $Y=0
X5 1 Contact_CDNS_7833375749229 $T=2065 115 0 0 $X=2065 $Y=0
M0 1 1 1 1 pmos1v2hvt L=2e-06 W=2.5e-05 AD=7.5e-12 AS=7.5e-12 PD=2.56e-05 PS=2.56e-05 m=1 $X=0 $Y=0 $dt=2
.ends pmos1v2hvt_4_CDNS_7833375749242

* +++++++++++++++++++++++++++++++++++++++++++++++++++++++++ *
* Sub cell: nmos1v2hvt_4_CDNS_7833375749243                 *
* +++++++++++++++++++++++++++++++++++++++++++++++++++++++++ *
.subckt nmos1v2hvt_4_CDNS_7833375749243 1 2 3 4
** N=4 EP=4 FDC=2
X0 2 Contact_CDNS_7833375749234 $T=-245 180 0 0 $X=-245 $Y=55
X1 4 Contact_CDNS_7833375749234 $T=4095 180 0 0 $X=4095 $Y=55
X2 2 Contact_CDNS_7833375749234 $T=8435 180 0 0 $X=8435 $Y=55
X3 2 Contact_CDNS_7833375749236 $T=-275 15 0 0 $X=-275 $Y=0
X4 4 Contact_CDNS_7833375749236 $T=4065 15 0 0 $X=4065 $Y=0
X5 2 Contact_CDNS_7833375749236 $T=8405 15 0 0 $X=8405 $Y=0
M0 4 1 2 3 nmos1v2hvt L=4e-06 W=8e-06 AD=2.72e-12 AS=2.4e-12 PD=8.68e-06 PS=8.6e-06 m=1 $X=0 $Y=0 $dt=1
M1 2 1 4 3 nmos1v2hvt L=4e-06 W=8e-06 AD=2.4e-12 AS=2.72e-12 PD=8.6e-06 PS=8.68e-06 m=1 $X=4340 $Y=0 $dt=1
.ends nmos1v2hvt_4_CDNS_7833375749243

* +++++++++++++++++++++++++++++++++++++++++++++++++++++++++ *
* Sub cell: rnpolym_CDNS_7833375749246                      *
* +++++++++++++++++++++++++++++++++++++++++++++++++++++++++ *
.subckt rnpolym_CDNS_7833375749246 1
** N=1 EP=1 FDC=1
X0 1 Contact_CDNS_7833375749214 $T=-30 -520 0 0 $X=-50 $Y=-540
X1 1 Contact_CDNS_7833375749214 $T=-30 35260 0 0 $X=-50 $Y=35240
R0 1 1 16727.1 L=3.5e-05 W=5e-07 $[rnpolym] $SUB=1 $X=0 $Y=0 $dt=3
.ends rnpolym_CDNS_7833375749246

* +++++++++++++++++++++++++++++++++++++++++++++++++++++++++ *
* Sub cell: Contact_CDNS_7833375749248                      *
* +++++++++++++++++++++++++++++++++++++++++++++++++++++++++ *
.subckt Contact_CDNS_7833375749248 1
** N=1 EP=1 FDC=0
.ends Contact_CDNS_7833375749248

* +++++++++++++++++++++++++++++++++++++++++++++++++++++++++ *
* Sub cell: AbutContact_CDNS_7833375749249                  *
* +++++++++++++++++++++++++++++++++++++++++++++++++++++++++ *
.subckt AbutContact_CDNS_7833375749249 1 2
** N=2 EP=2 FDC=0
.ends AbutContact_CDNS_7833375749249

* +++++++++++++++++++++++++++++++++++++++++++++++++++++++++ *
* Sub cell: pmos1v2hvt_4_CDNS_7833375749247                 *
* +++++++++++++++++++++++++++++++++++++++++++++++++++++++++ *
.subckt pmos1v2hvt_4_CDNS_7833375749247 1 2 3 4 5
** N=5 EP=5 FDC=4
X0 2 5 Contact_CDNS_783337574921 $T=-245 130 0 0 $X=-245 $Y=0
X1 3 5 Contact_CDNS_783337574921 $T=2095 130 0 0 $X=2095 $Y=0
X2 2 5 Contact_CDNS_783337574921 $T=4435 130 0 0 $X=4435 $Y=0
X3 3 5 Contact_CDNS_783337574921 $T=6775 130 0 0 $X=6775 $Y=0
X4 2 5 Contact_CDNS_783337574921 $T=9115 130 0 0 $X=9115 $Y=0
X5 2 Contact_CDNS_783337574922 $T=-275 140 0 0 $X=-275 $Y=0
X6 3 Contact_CDNS_783337574922 $T=2065 140 0 0 $X=2065 $Y=0
X7 2 Contact_CDNS_783337574922 $T=4405 140 0 0 $X=4405 $Y=0
X8 3 Contact_CDNS_783337574922 $T=6745 140 0 0 $X=6745 $Y=0
X9 2 Contact_CDNS_783337574922 $T=9085 140 0 0 $X=9085 $Y=0
X10 1 Contact_CDNS_7833375749248 $T=930 10150 0 0 $X=905 $Y=10150
X11 4 5 AbutContact_CDNS_7833375749249 $T=-370 -560 0 0 $X=-520 $Y=-620
M0 3 1 2 4 pmos1v2hvt L=2e-06 W=1e-05 AD=3.4e-12 AS=3e-12 PD=1.068e-05 PS=1.06e-05 m=1 $X=0 $Y=0 $dt=2
M1 2 1 3 4 pmos1v2hvt L=2e-06 W=1e-05 AD=3.4e-12 AS=3.4e-12 PD=1.068e-05 PS=1.068e-05 m=1 $X=2340 $Y=0 $dt=2
M2 3 1 2 4 pmos1v2hvt L=2e-06 W=1e-05 AD=3.4e-12 AS=3.4e-12 PD=1.068e-05 PS=1.068e-05 m=1 $X=4680 $Y=0 $dt=2
M3 2 1 3 4 pmos1v2hvt L=2e-06 W=1e-05 AD=3e-12 AS=3.4e-12 PD=1.06e-05 PS=1.068e-05 m=1 $X=7020 $Y=0 $dt=2
.ends pmos1v2hvt_4_CDNS_7833375749247

* +++++++++++++++++++++++++++++++++++++++++++++++++++++++++ *
* Sub cell: pmos1v2hvt_4_CDNS_7833375749250                 *
* +++++++++++++++++++++++++++++++++++++++++++++++++++++++++ *
.subckt pmos1v2hvt_4_CDNS_7833375749250 1 2 3 4 5
** N=5 EP=5 FDC=1
X0 2 5 Contact_CDNS_783337574921 $T=-245 130 0 0 $X=-245 $Y=0
X1 3 5 Contact_CDNS_783337574921 $T=2095 130 0 0 $X=2095 $Y=0
X2 2 Contact_CDNS_783337574922 $T=-275 140 0 0 $X=-275 $Y=0
X3 3 Contact_CDNS_783337574922 $T=2065 140 0 0 $X=2065 $Y=0
X4 4 5 AbutContact_CDNS_783337574924 $T=-430 -560 0 0 $X=-520 $Y=-620
M0 3 1 2 4 pmos1v2hvt L=2e-06 W=1e-05 AD=3e-12 AS=3e-12 PD=1.06e-05 PS=1.06e-05 m=1 $X=0 $Y=0 $dt=2
.ends pmos1v2hvt_4_CDNS_7833375749250

* +++++++++++++++++++++++++++++++++++++++++++++++++++++++++ *
* Sub cell: pmos1v2hvt_4_CDNS_7833375749252                 *
* +++++++++++++++++++++++++++++++++++++++++++++++++++++++++ *
.subckt pmos1v2hvt_4_CDNS_7833375749252 1 2 3 4 5
** N=5 EP=5 FDC=4
X0 2 5 Contact_CDNS_783337574921 $T=-245 130 0 0 $X=-245 $Y=0
X1 3 5 Contact_CDNS_783337574921 $T=2095 130 0 0 $X=2095 $Y=0
X2 2 5 Contact_CDNS_783337574921 $T=4435 130 0 0 $X=4435 $Y=0
X3 3 5 Contact_CDNS_783337574921 $T=6775 130 0 0 $X=6775 $Y=0
X4 2 5 Contact_CDNS_783337574921 $T=9115 130 0 0 $X=9115 $Y=0
X5 2 Contact_CDNS_783337574922 $T=-275 140 0 0 $X=-275 $Y=0
X6 3 Contact_CDNS_783337574922 $T=2065 140 0 0 $X=2065 $Y=0
X7 2 Contact_CDNS_783337574922 $T=4405 140 0 0 $X=4405 $Y=0
X8 3 Contact_CDNS_783337574922 $T=6745 140 0 0 $X=6745 $Y=0
X9 2 Contact_CDNS_783337574922 $T=9085 140 0 0 $X=9085 $Y=0
X10 4 5 AbutContact_CDNS_7833375749249 $T=-370 -560 0 0 $X=-520 $Y=-620
M0 3 1 2 4 pmos1v2hvt L=2e-06 W=1e-05 AD=3.4e-12 AS=3e-12 PD=1.068e-05 PS=1.06e-05 m=1 $X=0 $Y=0 $dt=2
M1 2 1 3 4 pmos1v2hvt L=2e-06 W=1e-05 AD=3.4e-12 AS=3.4e-12 PD=1.068e-05 PS=1.068e-05 m=1 $X=2340 $Y=0 $dt=2
M2 3 1 2 4 pmos1v2hvt L=2e-06 W=1e-05 AD=3.4e-12 AS=3.4e-12 PD=1.068e-05 PS=1.068e-05 m=1 $X=4680 $Y=0 $dt=2
M3 2 1 3 4 pmos1v2hvt L=2e-06 W=1e-05 AD=3e-12 AS=3.4e-12 PD=1.06e-05 PS=1.068e-05 m=1 $X=7020 $Y=0 $dt=2
.ends pmos1v2hvt_4_CDNS_7833375749252

* +++++++++++++++++++++++++++++++++++++++++++++++++++++++++ *
* Sub cell: Contact_CDNS_7833375749239                      *
* +++++++++++++++++++++++++++++++++++++++++++++++++++++++++ *
.subckt Contact_CDNS_7833375749239 1 2
** N=2 EP=2 FDC=0
.ends Contact_CDNS_7833375749239

* +++++++++++++++++++++++++++++++++++++++++++++++++++++++++ *
* Sub cell: Contact_CDNS_7833375749240                      *
* +++++++++++++++++++++++++++++++++++++++++++++++++++++++++ *
.subckt Contact_CDNS_7833375749240 1
** N=1 EP=1 FDC=0
.ends Contact_CDNS_7833375749240

* +++++++++++++++++++++++++++++++++++++++++++++++++++++++++ *
* Sub cell: AbutContact_CDNS_7833375749241                  *
* +++++++++++++++++++++++++++++++++++++++++++++++++++++++++ *
.subckt AbutContact_CDNS_7833375749241 1
** N=1 EP=1 FDC=0
.ends AbutContact_CDNS_7833375749241

* +++++++++++++++++++++++++++++++++++++++++++++++++++++++++ *
* Sub cell: nmos1v2hvt_4_CDNS_7833375749238                 *
* +++++++++++++++++++++++++++++++++++++++++++++++++++++++++ *
.subckt nmos1v2hvt_4_CDNS_7833375749238 1 2 3 4
** N=4 EP=4 FDC=1
X0 1 Contact_CDNS_783337574923 $T=120 18890 0 0 $X=0 $Y=18890
X1 2 4 Contact_CDNS_7833375749239 $T=-245 155 0 0 $X=-245 $Y=55
X2 3 4 Contact_CDNS_7833375749239 $T=2095 155 0 0 $X=2095 $Y=55
X3 2 Contact_CDNS_7833375749240 $T=-275 140 0 0 $X=-275 $Y=0
X4 3 Contact_CDNS_7833375749240 $T=2065 140 0 0 $X=2065 $Y=0
X5 4 AbutContact_CDNS_7833375749241 $T=-430 -560 0 0 $X=-520 $Y=-620
M0 3 1 2 4 nmos1v2hvt L=2e-06 W=1.875e-05 AD=5.625e-12 AS=5.625e-12 PD=1.935e-05 PS=1.935e-05 m=1 $X=0 $Y=0 $dt=1
.ends nmos1v2hvt_4_CDNS_7833375749238

* +++++++++++++++++++++++++++++++++++++++++++++++++++++++++ *
* Sub cell: MASCO__A2                                       *
* +++++++++++++++++++++++++++++++++++++++++++++++++++++++++ *
.subckt MASCO__A2 1 2 3 4 5 6 7
** N=7 EP=7 FDC=2
X0 1 5 4 3 nmos1v2hvt_4_CDNS_7833375749238 $T=620 19150 1 0 $X=0 $Y=0
X1 2 7 6 3 nmos1v2hvt_4_CDNS_7833375749238 $T=3860 19150 1 0 $X=3240 $Y=0
.ends MASCO__A2

* +++++++++++++++++++++++++++++++++++++++++++++++++++++++++ *
* Sub cell: MASCO__A3                                       *
* +++++++++++++++++++++++++++++++++++++++++++++++++++++++++ *
.subckt MASCO__A3 1 2 3 4 5 6 7 8
** N=8 EP=8 FDC=2
X0 1 6 5 3 nmos1v2hvt_4_CDNS_7833375749238 $T=620 720 0 0 $X=0 $Y=0
X1 2 8 7 3 nmos1v2hvt_4_CDNS_7833375749238 $T=3860 720 0 0 $X=3240 $Y=0
.ends MASCO__A3

* +++++++++++++++++++++++++++++++++++++++++++++++++++++++++ *
* Sub cell: MASCO__A1                                       *
* +++++++++++++++++++++++++++++++++++++++++++++++++++++++++ *
.subckt MASCO__A1 1 2 3 4 5 6
** N=6 EP=6 FDC=2
X0 1 2 3 2 6 pmos1v2hvt_4_CDNS_783337574920 $T=620 10400 1 0 $X=0 $Y=0
X1 4 2 5 2 6 pmos1v2hvt_4_CDNS_783337574920 $T=3860 10400 1 0 $X=3240 $Y=0
.ends MASCO__A1

* +++++++++++++++++++++++++++++++++++++++++++++++++++++++++ *
* Sub cell: MASCO__A4                                       *
* +++++++++++++++++++++++++++++++++++++++++++++++++++++++++ *
.subckt MASCO__A4 1 2 3 4 5 6 7 8 9
** N=9 EP=9 FDC=4
X0 1 3 7 2 4 9 MASCO__A1 $T=0 0 0 0 $X=0 $Y=0
X1 2 3 6 5 8 9 MASCO__A1 $T=6480 0 0 0 $X=6480 $Y=0
.ends MASCO__A4

* +++++++++++++++++++++++++++++++++++++++++++++++++++++++++ *
* Sub cell: MASCO__A5                                       *
* +++++++++++++++++++++++++++++++++++++++++++++++++++++++++ *
.subckt MASCO__A5 1 2 3 4 5 6 7 8 9
** N=9 EP=9 FDC=4
X0 1 2 3 8 9 5 4 MASCO__A2 $T=0 0 0 0 $X=0 $Y=0
X1 6 2 3 7 4 5 4 MASCO__A2 $T=6480 0 0 0 $X=6480 $Y=0
.ends MASCO__A5

* +++++++++++++++++++++++++++++++++++++++++++++++++++++++++ *
* Sub cell: MASCO__A6                                       *
* +++++++++++++++++++++++++++++++++++++++++++++++++++++++++ *
.subckt MASCO__A6 1 2 3 4 5 6 7 8 9
** N=9 EP=9 FDC=4
X0 1 2 3 4 8 9 5 4 MASCO__A3 $T=0 0 0 0 $X=0 $Y=0
X1 6 2 3 4 7 4 5 4 MASCO__A3 $T=6480 0 0 0 $X=6480 $Y=0
.ends MASCO__A6

* +++++++++++++++++++++++++++++++++++++++++++++++++++++++++ *
* Sub cell: MASCO__A7                                       *
* +++++++++++++++++++++++++++++++++++++++++++++++++++++++++ *
.subckt MASCO__A7 1 2 3 4 5 6 7 8 9 10
+ 11 12
** N=12 EP=12 FDC=8
X0 2 1 3 4 1 5 11 6 12 MASCO__A4 $T=0 0 0 0 $X=0 $Y=0
X1 1 1 3 8 1 9 7 10 12 MASCO__A4 $T=12960 0 0 0 $X=12960 $Y=0
.ends MASCO__A7

* +++++++++++++++++++++++++++++++++++++++++++++++++++++++++ *
* Sub cell: REF_V5_fL                                       *
* +++++++++++++++++++++++++++++++++++++++++++++++++++++++++ *
.subckt REF_V5_fL 95 96 97 98 99 100 101 102 2 43
+ 125 52 54 56 58 127 60 62 64 66
+ 68 129 70 72 74 76 78 131 80 82
+ 84 86 88 133 48 121 123 16 50 135
+ 91 103 104 105 106 92 111 112 113 114
+ 116 115 117 118 38 90 49
** N=135 EP=57 FDC=758
X0 1 M1_M2_CDNS_783337574920 $T=23755 35890 0 0 $X=23475 $Y=35755
X1 2 M1_M2_CDNS_783337574920 $T=24095 35370 0 180 $X=23815 $Y=35235
X2 1 M1_M2_CDNS_783337574920 $T=26445 35820 0 0 $X=26165 $Y=35685
X3 2 M1_M2_CDNS_783337574920 $T=27885 35440 0 180 $X=27605 $Y=35305
X4 1 M1_M2_CDNS_783337574920 $T=30235 35890 0 0 $X=29955 $Y=35755
X5 2 M1_M2_CDNS_783337574920 $T=30575 35370 0 180 $X=30295 $Y=35235
X6 1 M1_M2_CDNS_783337574920 $T=32925 35820 0 0 $X=32645 $Y=35685
X7 2 M1_M2_CDNS_783337574920 $T=34365 35440 0 180 $X=34085 $Y=35305
X8 1 M1_M2_CDNS_783337574920 $T=36715 35890 0 0 $X=36435 $Y=35755
X9 2 M1_M2_CDNS_783337574920 $T=37055 35370 0 180 $X=36775 $Y=35235
X10 1 M1_M2_CDNS_783337574920 $T=39405 35820 0 0 $X=39125 $Y=35685
X11 2 M1_M2_CDNS_783337574920 $T=40845 35440 0 180 $X=40565 $Y=35305
X12 1 M1_M2_CDNS_783337574920 $T=43195 35890 0 0 $X=42915 $Y=35755
X13 2 M1_M2_CDNS_783337574920 $T=43535 35370 0 180 $X=43255 $Y=35235
X14 1 M1_M2_CDNS_783337574920 $T=45885 35820 0 0 $X=45605 $Y=35685
X15 2 M1_M2_CDNS_783337574920 $T=47325 35440 0 180 $X=47045 $Y=35305
X16 1 M1_M2_CDNS_783337574920 $T=49675 35890 0 0 $X=49395 $Y=35755
X17 2 M1_M2_CDNS_783337574920 $T=50015 35370 0 180 $X=49735 $Y=35235
X18 1 M1_M2_CDNS_783337574920 $T=52365 35820 0 0 $X=52085 $Y=35685
X19 2 M1_M2_CDNS_783337574920 $T=53805 35440 0 180 $X=53525 $Y=35305
X20 1 M1_M2_CDNS_783337574920 $T=56155 35890 0 0 $X=55875 $Y=35755
X21 2 M1_M2_CDNS_783337574920 $T=56495 35370 0 180 $X=56215 $Y=35235
X22 1 M1_M2_CDNS_783337574920 $T=58845 35820 0 0 $X=58565 $Y=35685
X23 2 M1_M2_CDNS_783337574920 $T=60285 35440 0 180 $X=60005 $Y=35305
X24 1 M1_M2_CDNS_783337574920 $T=62635 35890 0 0 $X=62355 $Y=35755
X25 2 M1_M2_CDNS_783337574920 $T=62975 35370 0 180 $X=62695 $Y=35235
X26 1 M1_M2_CDNS_783337574920 $T=65325 35820 0 0 $X=65045 $Y=35685
X27 2 M1_M2_CDNS_783337574920 $T=66765 35440 0 180 $X=66485 $Y=35305
X28 1 M1_M2_CDNS_783337574920 $T=69115 35890 0 0 $X=68835 $Y=35755
X29 2 M1_M2_CDNS_783337574920 $T=69455 35370 0 180 $X=69175 $Y=35235
X30 1 M1_M2_CDNS_783337574920 $T=71805 35820 0 0 $X=71525 $Y=35685
X31 2 M1_M2_CDNS_783337574920 $T=73245 35440 0 180 $X=72965 $Y=35305
X32 2 M1_M2_CDNS_783337574920 $T=75045 35440 1 0 $X=74765 $Y=35305
X33 1 M1_M2_CDNS_783337574920 $T=76485 35820 1 180 $X=76205 $Y=35685
X34 2 M1_M2_CDNS_783337574920 $T=78835 35370 1 0 $X=78555 $Y=35235
X35 1 M1_M2_CDNS_783337574920 $T=79175 35890 1 180 $X=78895 $Y=35755
X36 2 M1_M2_CDNS_783337574920 $T=81525 35440 1 0 $X=81245 $Y=35305
X37 1 M1_M2_CDNS_783337574920 $T=82965 35820 1 180 $X=82685 $Y=35685
X38 2 M1_M2_CDNS_783337574920 $T=85315 35370 1 0 $X=85035 $Y=35235
X39 1 M1_M2_CDNS_783337574920 $T=85655 35890 1 180 $X=85375 $Y=35755
X40 2 M1_M2_CDNS_783337574920 $T=88005 35440 1 0 $X=87725 $Y=35305
X41 1 M1_M2_CDNS_783337574920 $T=89445 35820 1 180 $X=89165 $Y=35685
X42 2 M1_M2_CDNS_783337574920 $T=91795 35370 1 0 $X=91515 $Y=35235
X43 1 M1_M2_CDNS_783337574920 $T=92135 35890 1 180 $X=91855 $Y=35755
X44 2 M1_M2_CDNS_783337574920 $T=94485 35440 1 0 $X=94205 $Y=35305
X45 1 M1_M2_CDNS_783337574920 $T=95925 35820 1 180 $X=95645 $Y=35685
X46 2 M1_M2_CDNS_783337574920 $T=98275 35370 1 0 $X=97995 $Y=35235
X47 1 M1_M2_CDNS_783337574920 $T=98615 35890 1 180 $X=98335 $Y=35755
X48 2 M1_M2_CDNS_783337574920 $T=100965 35440 1 0 $X=100685 $Y=35305
X49 1 M1_M2_CDNS_783337574920 $T=102405 35820 1 180 $X=102125 $Y=35685
X50 2 M1_M2_CDNS_783337574920 $T=104755 35370 1 0 $X=104475 $Y=35235
X51 1 M1_M2_CDNS_783337574920 $T=105095 35890 1 180 $X=104815 $Y=35755
X52 2 M1_M2_CDNS_783337574920 $T=107445 35440 1 0 $X=107165 $Y=35305
X53 1 M1_M2_CDNS_783337574920 $T=108885 35820 1 180 $X=108605 $Y=35685
X54 2 M1_M2_CDNS_783337574920 $T=111235 35370 1 0 $X=110955 $Y=35235
X55 1 M1_M2_CDNS_783337574920 $T=111575 35890 1 180 $X=111295 $Y=35755
X56 2 M1_M2_CDNS_783337574920 $T=113925 35440 1 0 $X=113645 $Y=35305
X57 1 M1_M2_CDNS_783337574920 $T=115365 35820 1 180 $X=115085 $Y=35685
X58 2 M1_M2_CDNS_783337574920 $T=117715 35370 1 0 $X=117435 $Y=35235
X59 1 M1_M2_CDNS_783337574920 $T=118055 35890 1 180 $X=117775 $Y=35755
X60 2 M1_M2_CDNS_783337574920 $T=120405 35440 1 0 $X=120125 $Y=35305
X61 1 M1_M2_CDNS_783337574920 $T=121845 35820 1 180 $X=121565 $Y=35685
X62 2 M1_M2_CDNS_783337574920 $T=124195 35370 1 0 $X=123915 $Y=35235
X63 1 M1_M2_CDNS_783337574920 $T=124535 35890 1 180 $X=124255 $Y=35755
X64 3 M1_M2_CDNS_783337574920 $T=138960 34820 0 0 $X=138680 $Y=34685
X65 4 M1_M2_CDNS_783337574920 $T=138960 45305 0 0 $X=138680 $Y=45170
X66 5 M1_M2_CDNS_783337574920 $T=338660 25620 0 0 $X=338380 $Y=25485
X67 6 M1_M2_CDNS_783337574920 $T=339860 25105 0 0 $X=339580 $Y=24970
X68 7 M1_M2_CDNS_783337574920 $T=341060 24550 0 0 $X=340780 $Y=24415
X69 8 M1_M2_CDNS_783337574920 $T=341185 54125 0 0 $X=340905 $Y=53990
X70 9 M1_M2_CDNS_783337574920 $T=342265 24010 0 0 $X=341985 $Y=23875
X71 10 M1_M2_CDNS_783337574920 $T=342390 54630 0 0 $X=342110 $Y=54495
X72 11 M1_M2_CDNS_783337574920 $T=343585 55125 0 0 $X=343305 $Y=54990
X73 12 M1_M2_CDNS_783337574920 $T=344785 55645 0 0 $X=344505 $Y=55510
X74 13 M1_M2_CDNS_783337574920 $T=345985 56155 0 0 $X=345705 $Y=56020
X75 14 M1_M2_CDNS_783337574920 $T=347185 56720 0 0 $X=346905 $Y=56585
X76 15 M1_M2_CDNS_783337574920 $T=348380 57225 0 0 $X=348100 $Y=57090
X77 16 M1_M2_CDNS_783337574922 $T=4190 28785 0 0 $X=3910 $Y=28475
X78 17 M1_M2_CDNS_783337574922 $T=5910 27840 0 0 $X=5630 $Y=27530
X79 18 M1_M2_CDNS_783337574922 $T=8170 28430 0 0 $X=7890 $Y=28120
X80 17 M1_M2_CDNS_783337574922 $T=9850 27445 0 0 $X=9570 $Y=27135
X81 18 M1_M2_CDNS_783337574922 $T=12325 27450 0 0 $X=12045 $Y=27140
X82 17 M1_M2_CDNS_783337574922 $T=129380 8100 0 0 $X=129100 $Y=7790
X83 1 M1_M2_CDNS_783337574922 $T=130840 35850 0 0 $X=130560 $Y=35540
X84 19 M1_M2_CDNS_783337574922 $T=132975 15480 0 0 $X=132695 $Y=15170
X85 1 M1_M2_CDNS_783337574922 $T=149855 46530 0 0 $X=149575 $Y=46220
X86 20 M1_M2_CDNS_783337574922 $T=176315 44490 0 0 $X=176035 $Y=44180
X87 20 M1_M2_CDNS_783337574922 $T=176315 46990 0 0 $X=176035 $Y=46680
X88 21 M1_M2_CDNS_783337574922 $T=186760 43670 0 0 $X=186480 $Y=43360
X89 22 M1_M2_CDNS_783337574922 $T=188800 48950 0 0 $X=188520 $Y=48640
X90 23 M1_M2_CDNS_783337574922 $T=199290 41470 0 0 $X=199010 $Y=41160
X91 24 M1_M2_CDNS_783337574922 $T=199320 50270 0 0 $X=199040 $Y=49960
X92 25 M1_M2_CDNS_783337574922 $T=208685 39270 0 0 $X=208405 $Y=38960
X93 26 M1_M2_CDNS_783337574922 $T=208700 52475 0 0 $X=208420 $Y=52165
X94 27 M1_M2_CDNS_783337574922 $T=218655 37070 0 0 $X=218375 $Y=36760
X95 28 M1_M2_CDNS_783337574922 $T=315685 81670 0 0 $X=315405 $Y=81360
X96 29 M1_M2_CDNS_783337574922 $T=315695 9815 0 0 $X=315415 $Y=9505
X97 28 M1_M2_CDNS_783337574922 $T=317185 81670 0 0 $X=316905 $Y=81360
X98 29 M1_M2_CDNS_783337574922 $T=317190 9810 0 0 $X=316910 $Y=9500
X99 30 M1_M2_CDNS_783337574922 $T=317935 45270 0 0 $X=317655 $Y=44960
X100 30 M1_M2_CDNS_783337574922 $T=317935 46755 0 0 $X=317655 $Y=46445
X101 31 M1_M2_CDNS_783337574922 $T=319425 26685 0 0 $X=319145 $Y=26375
X102 32 M1_M2_CDNS_783337574922 $T=322430 28940 0 0 $X=322150 $Y=28630
X103 33 M1_M2_CDNS_783337574922 $T=323180 44390 0 0 $X=322900 $Y=44080
X104 33 M1_M2_CDNS_783337574922 $T=323180 47380 0 0 $X=322900 $Y=47070
X105 34 M1_M2_CDNS_783337574922 $T=323935 45270 0 0 $X=323655 $Y=44960
X106 34 M1_M2_CDNS_783337574922 $T=323935 46740 0 0 $X=323655 $Y=46430
X107 35 M1_M2_CDNS_783337574922 $T=324690 44245 0 0 $X=324410 $Y=43935
X108 35 M1_M2_CDNS_783337574922 $T=324690 47400 0 0 $X=324410 $Y=47090
X109 36 M1_M2_CDNS_783337574922 $T=325435 31165 0 0 $X=325155 $Y=30855
X110 36 M1_M2_CDNS_783337574922 $T=325435 45270 0 0 $X=325155 $Y=44960
X111 36 M1_M2_CDNS_783337574922 $T=325435 46740 0 0 $X=325155 $Y=46430
X112 37 M1_M2_CDNS_783337574922 $T=326560 45270 0 0 $X=326280 $Y=44960
X113 37 M1_M2_CDNS_783337574922 $T=326560 46740 0 0 $X=326280 $Y=46430
X114 38 M1_M2_CDNS_783337574922 $T=327685 45270 0 0 $X=327405 $Y=44960
X115 33 M1_M2_CDNS_783337574922 $T=329065 59110 0 0 $X=328785 $Y=58800
X116 34 M1_M2_CDNS_783337574922 $T=329585 61350 0 0 $X=329305 $Y=61040
X117 35 M1_M2_CDNS_783337574922 $T=330035 63595 0 0 $X=329755 $Y=63285
X118 36 M1_M2_CDNS_783337574922 $T=330685 65875 0 0 $X=330405 $Y=65565
X119 39 M1_M2_CDNS_783337574922 $T=331405 44480 0 0 $X=331125 $Y=44170
X120 39 M1_M2_CDNS_783337574922 $T=331405 47535 0 0 $X=331125 $Y=47225
X121 39 M1_M2_CDNS_783337574922 $T=331405 68070 0 0 $X=331125 $Y=67760
X122 37 M1_M2_CDNS_783337574922 $T=332285 70245 0 0 $X=332005 $Y=69935
X123 30 M1_M2_CDNS_783337574922 $T=332960 74790 0 0 $X=332680 $Y=74480
X124 40 M1_M2_CDNS_783337574922 $T=333055 44430 0 0 $X=332775 $Y=44120
X125 40 M1_M2_CDNS_783337574922 $T=333055 46690 0 0 $X=332775 $Y=46380
X126 40 M1_M2_CDNS_783337574922 $T=333055 72550 0 0 $X=332775 $Y=72240
X127 41 M1_M2_CDNS_783337574923 $T=110355 107660 0 0 $X=109725 $Y=107525
X128 38 M1_M2_CDNS_783337574923 $T=112430 107910 0 0 $X=111800 $Y=107775
X129 38 M1_M2_CDNS_783337574923 $T=122150 107910 0 0 $X=121520 $Y=107775
X130 38 M1_M2_CDNS_783337574923 $T=125390 107910 0 0 $X=124760 $Y=107775
X131 38 M1_M2_CDNS_783337574923 $T=128630 107910 0 0 $X=128000 $Y=107775
X132 38 M1_M2_CDNS_783337574923 $T=144830 107910 0 0 $X=144200 $Y=107775
X133 38 M1_M2_CDNS_783337574923 $T=161030 107910 0 0 $X=160400 $Y=107775
X134 38 M1_M2_CDNS_783337574923 $T=167510 107910 0 0 $X=166880 $Y=107775
X135 38 M1_M2_CDNS_783337574923 $T=173990 107910 0 0 $X=173360 $Y=107775
X136 38 M1_M2_CDNS_783337574923 $T=180470 107910 0 0 $X=179840 $Y=107775
X137 38 M1_M2_CDNS_783337574923 $T=186950 107910 0 0 $X=186320 $Y=107775
X138 38 M1_M2_CDNS_783337574923 $T=193430 107910 0 0 $X=192800 $Y=107775
X139 38 M1_M2_CDNS_783337574923 $T=199910 107910 0 0 $X=199280 $Y=107775
X140 38 M1_M2_CDNS_783337574923 $T=206390 107910 0 0 $X=205760 $Y=107775
X141 38 M1_M2_CDNS_783337574923 $T=212870 107910 0 0 $X=212240 $Y=107775
X142 38 M1_M2_CDNS_783337574923 $T=219350 107910 0 0 $X=218720 $Y=107775
X143 38 M1_M2_CDNS_783337574923 $T=225830 107910 0 0 $X=225200 $Y=107775
X144 38 M1_M2_CDNS_783337574923 $T=232310 107910 0 0 $X=231680 $Y=107775
X145 38 M1_M2_CDNS_783337574923 $T=238790 107910 0 0 $X=238160 $Y=107775
X146 38 M1_M2_CDNS_783337574923 $T=245270 107910 0 0 $X=244640 $Y=107775
X147 38 M1_M2_CDNS_783337574923 $T=251750 107910 0 0 $X=251120 $Y=107775
X148 38 M1_M2_CDNS_783337574923 $T=258230 107910 0 0 $X=257600 $Y=107775
X149 38 M1_M2_CDNS_783337574923 $T=264710 107910 0 0 $X=264080 $Y=107775
X150 38 M1_M2_CDNS_783337574923 $T=271190 107910 0 0 $X=270560 $Y=107775
X151 38 M1_M2_CDNS_783337574923 $T=277670 107910 0 0 $X=277040 $Y=107775
X152 38 M1_M2_CDNS_783337574923 $T=284150 107910 0 0 $X=283520 $Y=107775
X153 38 M1_M2_CDNS_783337574923 $T=290630 107910 0 0 $X=290000 $Y=107775
X154 38 M1_M2_CDNS_783337574923 $T=297110 107910 0 0 $X=296480 $Y=107775
X155 38 M1_M2_CDNS_783337574923 $T=303590 107910 0 0 $X=302960 $Y=107775
X156 38 M1_M2_CDNS_783337574923 $T=310070 107910 0 0 $X=309440 $Y=107775
X157 38 M1_M2_CDNS_783337574923 $T=326270 107910 0 0 $X=325640 $Y=107775
X158 38 M1_M2_CDNS_783337574923 $T=332750 107910 0 0 $X=332120 $Y=107775
X159 38 M1_M2_CDNS_783337574923 $T=339230 107910 0 0 $X=338600 $Y=107775
X160 38 M1_M2_CDNS_783337574923 $T=345710 107910 0 0 $X=345080 $Y=107775
X161 38 M1_M2_CDNS_783337574923 $T=352190 107910 0 0 $X=351560 $Y=107775
X162 38 M1_M2_CDNS_783337574923 $T=358670 107910 0 0 $X=358040 $Y=107775
X163 38 M1_M2_CDNS_783337574923 $T=374870 107910 0 0 $X=374240 $Y=107775
X164 38 M1_M2_CDNS_783337574923 $T=391070 107910 0 0 $X=390440 $Y=107775
X165 38 M1_M2_CDNS_783337574923 $T=394310 107910 0 0 $X=393680 $Y=107775
X166 38 M1_M2_CDNS_783337574923 $T=397550 107910 0 0 $X=396920 $Y=107775
X167 38 M1_M2_CDNS_783337574923 $T=400790 107910 0 0 $X=400160 $Y=107775
X168 16 PG_M1_CDNS_783337574924 $T=4810 28020 0 0 $X=4530 $Y=27740
X169 17 PG_M1_CDNS_783337574924 $T=7050 27975 0 0 $X=6770 $Y=27695
X170 18 PG_M1_CDNS_783337574924 $T=8595 60610 0 0 $X=8315 $Y=60330
X171 18 PG_M1_CDNS_783337574924 $T=8595 62350 0 0 $X=8315 $Y=62070
X172 17 PG_M1_CDNS_783337574924 $T=9850 27450 0 0 $X=9570 $Y=27170
X173 18 PG_M1_CDNS_783337574924 $T=12325 27450 0 0 $X=12045 $Y=27170
X174 17 PG_M1_CDNS_783337574924 $T=129385 8070 0 0 $X=129105 $Y=7790
X175 42 M1_M2_CDNS_783337574925 $T=10300 26300 0 0 $X=10195 $Y=25990
X176 5 M1_M2_CDNS_783337574925 $T=338840 21685 0 0 $X=338735 $Y=21375
X177 6 M1_M2_CDNS_783337574925 $T=340035 21685 0 0 $X=339930 $Y=21375
X178 7 M1_M2_CDNS_783337574925 $T=341240 21685 0 0 $X=341135 $Y=21375
X179 8 M1_M2_CDNS_783337574925 $T=341360 52440 0 0 $X=341255 $Y=52130
X180 9 M1_M2_CDNS_783337574925 $T=342445 21685 0 0 $X=342340 $Y=21375
X181 10 M1_M2_CDNS_783337574925 $T=342560 52440 0 0 $X=342455 $Y=52130
X182 11 M1_M2_CDNS_783337574925 $T=343760 52440 0 0 $X=343655 $Y=52130
X183 12 M1_M2_CDNS_783337574925 $T=344960 52440 0 0 $X=344855 $Y=52130
X184 13 M1_M2_CDNS_783337574925 $T=346160 52440 0 0 $X=346055 $Y=52130
X185 14 M1_M2_CDNS_783337574925 $T=347360 52440 0 0 $X=347255 $Y=52130
X186 15 M1_M2_CDNS_783337574925 $T=348560 52440 0 0 $X=348455 $Y=52130
X187 42 M1_M2_CDNS_783337574926 $T=11700 26505 0 0 $X=11420 $Y=26020
X188 43 M1_M2_CDNS_783337574926 $T=12945 26505 0 0 $X=12665 $Y=26020
X189 44 M2_M3_CDNS_783337574928 $T=23110 14445 1 0 $X=22585 $Y=14095
X190 44 M2_M3_CDNS_783337574928 $T=23110 56555 0 0 $X=22585 $Y=56205
X191 41 M2_M3_CDNS_783337574928 $T=25445 13145 1 0 $X=24920 $Y=12795
X192 45 M2_M3_CDNS_783337574928 $T=25445 57855 0 0 $X=24920 $Y=57505
X193 44 M2_M3_CDNS_783337574928 $T=26350 14445 1 0 $X=25825 $Y=14095
X194 44 M2_M3_CDNS_783337574928 $T=26350 56555 0 0 $X=25825 $Y=56205
X195 45 M2_M3_CDNS_783337574928 $T=28685 11845 1 0 $X=28160 $Y=11495
X196 41 M2_M3_CDNS_783337574928 $T=28685 59155 0 0 $X=28160 $Y=58805
X197 44 M2_M3_CDNS_783337574928 $T=29590 14445 1 0 $X=29065 $Y=14095
X198 44 M2_M3_CDNS_783337574928 $T=29590 56555 0 0 $X=29065 $Y=56205
X199 41 M2_M3_CDNS_783337574928 $T=31925 13145 1 0 $X=31400 $Y=12795
X200 45 M2_M3_CDNS_783337574928 $T=31925 57855 0 0 $X=31400 $Y=57505
X201 44 M2_M3_CDNS_783337574928 $T=32830 14445 1 0 $X=32305 $Y=14095
X202 44 M2_M3_CDNS_783337574928 $T=32830 56555 0 0 $X=32305 $Y=56205
X203 45 M2_M3_CDNS_783337574928 $T=35165 11845 1 0 $X=34640 $Y=11495
X204 41 M2_M3_CDNS_783337574928 $T=35165 59155 0 0 $X=34640 $Y=58805
X205 44 M2_M3_CDNS_783337574928 $T=36070 14445 1 0 $X=35545 $Y=14095
X206 44 M2_M3_CDNS_783337574928 $T=36070 56555 0 0 $X=35545 $Y=56205
X207 41 M2_M3_CDNS_783337574928 $T=38405 13145 1 0 $X=37880 $Y=12795
X208 45 M2_M3_CDNS_783337574928 $T=38405 57855 0 0 $X=37880 $Y=57505
X209 44 M2_M3_CDNS_783337574928 $T=39310 14445 1 0 $X=38785 $Y=14095
X210 44 M2_M3_CDNS_783337574928 $T=39310 56555 0 0 $X=38785 $Y=56205
X211 45 M2_M3_CDNS_783337574928 $T=41645 11845 1 0 $X=41120 $Y=11495
X212 41 M2_M3_CDNS_783337574928 $T=41645 59155 0 0 $X=41120 $Y=58805
X213 44 M2_M3_CDNS_783337574928 $T=42550 14445 1 0 $X=42025 $Y=14095
X214 44 M2_M3_CDNS_783337574928 $T=42550 56555 0 0 $X=42025 $Y=56205
X215 41 M2_M3_CDNS_783337574928 $T=44885 13145 1 0 $X=44360 $Y=12795
X216 45 M2_M3_CDNS_783337574928 $T=44885 57855 0 0 $X=44360 $Y=57505
X217 44 M2_M3_CDNS_783337574928 $T=45790 14445 1 0 $X=45265 $Y=14095
X218 44 M2_M3_CDNS_783337574928 $T=45790 56555 0 0 $X=45265 $Y=56205
X219 45 M2_M3_CDNS_783337574928 $T=48125 11845 1 0 $X=47600 $Y=11495
X220 41 M2_M3_CDNS_783337574928 $T=48125 59155 0 0 $X=47600 $Y=58805
X221 44 M2_M3_CDNS_783337574928 $T=49030 14445 1 0 $X=48505 $Y=14095
X222 44 M2_M3_CDNS_783337574928 $T=49030 56555 0 0 $X=48505 $Y=56205
X223 41 M2_M3_CDNS_783337574928 $T=51365 13145 1 0 $X=50840 $Y=12795
X224 45 M2_M3_CDNS_783337574928 $T=51365 57855 0 0 $X=50840 $Y=57505
X225 44 M2_M3_CDNS_783337574928 $T=52270 14445 1 0 $X=51745 $Y=14095
X226 44 M2_M3_CDNS_783337574928 $T=52270 56555 0 0 $X=51745 $Y=56205
X227 45 M2_M3_CDNS_783337574928 $T=54605 11845 1 0 $X=54080 $Y=11495
X228 41 M2_M3_CDNS_783337574928 $T=54605 59155 0 0 $X=54080 $Y=58805
X229 44 M2_M3_CDNS_783337574928 $T=55510 14445 1 0 $X=54985 $Y=14095
X230 44 M2_M3_CDNS_783337574928 $T=55510 56555 0 0 $X=54985 $Y=56205
X231 41 M2_M3_CDNS_783337574928 $T=57845 13145 1 0 $X=57320 $Y=12795
X232 45 M2_M3_CDNS_783337574928 $T=57845 57855 0 0 $X=57320 $Y=57505
X233 44 M2_M3_CDNS_783337574928 $T=58750 14445 1 0 $X=58225 $Y=14095
X234 44 M2_M3_CDNS_783337574928 $T=58750 56555 0 0 $X=58225 $Y=56205
X235 45 M2_M3_CDNS_783337574928 $T=61085 11845 1 0 $X=60560 $Y=11495
X236 41 M2_M3_CDNS_783337574928 $T=61085 59155 0 0 $X=60560 $Y=58805
X237 44 M2_M3_CDNS_783337574928 $T=61990 14445 1 0 $X=61465 $Y=14095
X238 44 M2_M3_CDNS_783337574928 $T=61990 56555 0 0 $X=61465 $Y=56205
X239 41 M2_M3_CDNS_783337574928 $T=64325 13145 1 0 $X=63800 $Y=12795
X240 45 M2_M3_CDNS_783337574928 $T=64325 57855 0 0 $X=63800 $Y=57505
X241 44 M2_M3_CDNS_783337574928 $T=65230 14445 1 0 $X=64705 $Y=14095
X242 44 M2_M3_CDNS_783337574928 $T=65230 56555 0 0 $X=64705 $Y=56205
X243 45 M2_M3_CDNS_783337574928 $T=67565 11845 1 0 $X=67040 $Y=11495
X244 41 M2_M3_CDNS_783337574928 $T=67565 59155 0 0 $X=67040 $Y=58805
X245 44 M2_M3_CDNS_783337574928 $T=68470 14445 1 0 $X=67945 $Y=14095
X246 44 M2_M3_CDNS_783337574928 $T=68470 56555 0 0 $X=67945 $Y=56205
X247 41 M2_M3_CDNS_783337574928 $T=70805 13145 1 0 $X=70280 $Y=12795
X248 45 M2_M3_CDNS_783337574928 $T=70805 57855 0 0 $X=70280 $Y=57505
X249 44 M2_M3_CDNS_783337574928 $T=71710 14445 1 0 $X=71185 $Y=14095
X250 44 M2_M3_CDNS_783337574928 $T=71710 56555 0 0 $X=71185 $Y=56205
X251 45 M2_M3_CDNS_783337574928 $T=74045 11845 1 0 $X=73520 $Y=11495
X252 41 M2_M3_CDNS_783337574928 $T=74045 59155 0 0 $X=73520 $Y=58805
X253 44 M2_M3_CDNS_783337574928 $T=74950 14445 1 0 $X=74425 $Y=14095
X254 44 M2_M3_CDNS_783337574928 $T=74950 56555 0 0 $X=74425 $Y=56205
X255 45 M2_M3_CDNS_783337574928 $T=77285 11845 1 0 $X=76760 $Y=11495
X256 41 M2_M3_CDNS_783337574928 $T=77285 59155 0 0 $X=76760 $Y=58805
X257 44 M2_M3_CDNS_783337574928 $T=78190 14445 1 0 $X=77665 $Y=14095
X258 44 M2_M3_CDNS_783337574928 $T=78190 56555 0 0 $X=77665 $Y=56205
X259 41 M2_M3_CDNS_783337574928 $T=80525 13145 1 0 $X=80000 $Y=12795
X260 45 M2_M3_CDNS_783337574928 $T=80525 57855 0 0 $X=80000 $Y=57505
X261 44 M2_M3_CDNS_783337574928 $T=81430 14445 1 0 $X=80905 $Y=14095
X262 44 M2_M3_CDNS_783337574928 $T=81430 56555 0 0 $X=80905 $Y=56205
X263 45 M2_M3_CDNS_783337574928 $T=83765 11845 1 0 $X=83240 $Y=11495
X264 41 M2_M3_CDNS_783337574928 $T=83765 59155 0 0 $X=83240 $Y=58805
X265 44 M2_M3_CDNS_783337574928 $T=84670 14445 1 0 $X=84145 $Y=14095
X266 44 M2_M3_CDNS_783337574928 $T=84670 56555 0 0 $X=84145 $Y=56205
X267 41 M2_M3_CDNS_783337574928 $T=87005 13145 1 0 $X=86480 $Y=12795
X268 45 M2_M3_CDNS_783337574928 $T=87005 57855 0 0 $X=86480 $Y=57505
X269 44 M2_M3_CDNS_783337574928 $T=87910 14445 1 0 $X=87385 $Y=14095
X270 44 M2_M3_CDNS_783337574928 $T=87910 56555 0 0 $X=87385 $Y=56205
X271 45 M2_M3_CDNS_783337574928 $T=90245 11845 1 0 $X=89720 $Y=11495
X272 41 M2_M3_CDNS_783337574928 $T=90245 59155 0 0 $X=89720 $Y=58805
X273 44 M2_M3_CDNS_783337574928 $T=91150 14445 1 0 $X=90625 $Y=14095
X274 44 M2_M3_CDNS_783337574928 $T=91150 56555 0 0 $X=90625 $Y=56205
X275 41 M2_M3_CDNS_783337574928 $T=93485 13145 1 0 $X=92960 $Y=12795
X276 45 M2_M3_CDNS_783337574928 $T=93485 57855 0 0 $X=92960 $Y=57505
X277 44 M2_M3_CDNS_783337574928 $T=94390 14445 1 0 $X=93865 $Y=14095
X278 44 M2_M3_CDNS_783337574928 $T=94390 56555 0 0 $X=93865 $Y=56205
X279 45 M2_M3_CDNS_783337574928 $T=96725 11845 1 0 $X=96200 $Y=11495
X280 41 M2_M3_CDNS_783337574928 $T=96725 59155 0 0 $X=96200 $Y=58805
X281 44 M2_M3_CDNS_783337574928 $T=97630 14445 1 0 $X=97105 $Y=14095
X282 44 M2_M3_CDNS_783337574928 $T=97630 56555 0 0 $X=97105 $Y=56205
X283 41 M2_M3_CDNS_783337574928 $T=99965 13145 1 0 $X=99440 $Y=12795
X284 45 M2_M3_CDNS_783337574928 $T=99965 57855 0 0 $X=99440 $Y=57505
X285 44 M2_M3_CDNS_783337574928 $T=100870 14445 1 0 $X=100345 $Y=14095
X286 44 M2_M3_CDNS_783337574928 $T=100870 56555 0 0 $X=100345 $Y=56205
X287 45 M2_M3_CDNS_783337574928 $T=103205 11845 1 0 $X=102680 $Y=11495
X288 41 M2_M3_CDNS_783337574928 $T=103205 59155 0 0 $X=102680 $Y=58805
X289 44 M2_M3_CDNS_783337574928 $T=104110 14445 1 0 $X=103585 $Y=14095
X290 44 M2_M3_CDNS_783337574928 $T=104110 56555 0 0 $X=103585 $Y=56205
X291 41 M2_M3_CDNS_783337574928 $T=106445 13145 1 0 $X=105920 $Y=12795
X292 45 M2_M3_CDNS_783337574928 $T=106445 57855 0 0 $X=105920 $Y=57505
X293 44 M2_M3_CDNS_783337574928 $T=107350 14445 1 0 $X=106825 $Y=14095
X294 44 M2_M3_CDNS_783337574928 $T=107350 56555 0 0 $X=106825 $Y=56205
X295 45 M2_M3_CDNS_783337574928 $T=109685 11845 1 0 $X=109160 $Y=11495
X296 41 M2_M3_CDNS_783337574928 $T=109685 59155 0 0 $X=109160 $Y=58805
X297 44 M2_M3_CDNS_783337574928 $T=110590 14445 1 0 $X=110065 $Y=14095
X298 44 M2_M3_CDNS_783337574928 $T=110590 56555 0 0 $X=110065 $Y=56205
X299 41 M2_M3_CDNS_783337574928 $T=112925 13145 1 0 $X=112400 $Y=12795
X300 45 M2_M3_CDNS_783337574928 $T=112925 57855 0 0 $X=112400 $Y=57505
X301 44 M2_M3_CDNS_783337574928 $T=113830 14445 1 0 $X=113305 $Y=14095
X302 44 M2_M3_CDNS_783337574928 $T=113830 56555 0 0 $X=113305 $Y=56205
X303 45 M2_M3_CDNS_783337574928 $T=116165 11845 1 0 $X=115640 $Y=11495
X304 41 M2_M3_CDNS_783337574928 $T=116165 59155 0 0 $X=115640 $Y=58805
X305 44 M2_M3_CDNS_783337574928 $T=117070 14445 1 0 $X=116545 $Y=14095
X306 44 M2_M3_CDNS_783337574928 $T=117070 56555 0 0 $X=116545 $Y=56205
X307 41 M2_M3_CDNS_783337574928 $T=119405 13145 1 0 $X=118880 $Y=12795
X308 45 M2_M3_CDNS_783337574928 $T=119405 57855 0 0 $X=118880 $Y=57505
X309 44 M2_M3_CDNS_783337574928 $T=120310 14445 1 0 $X=119785 $Y=14095
X310 44 M2_M3_CDNS_783337574928 $T=120310 56555 0 0 $X=119785 $Y=56205
X311 45 M2_M3_CDNS_783337574928 $T=122645 11845 1 0 $X=122120 $Y=11495
X312 41 M2_M3_CDNS_783337574928 $T=122645 59155 0 0 $X=122120 $Y=58805
X313 44 M2_M3_CDNS_783337574928 $T=123550 14445 1 0 $X=123025 $Y=14095
X314 44 M2_M3_CDNS_783337574928 $T=123550 56555 0 0 $X=123025 $Y=56205
X315 41 M2_M3_CDNS_783337574928 $T=125885 13145 1 0 $X=125360 $Y=12795
X316 45 M2_M3_CDNS_783337574928 $T=125885 57855 0 0 $X=125360 $Y=57505
X317 45 M1_M2_CDNS_783337574929 $T=7115 60135 0 0 $X=6135 $Y=60000
X318 41 M1_M2_CDNS_783337574929 $T=7115 61875 0 0 $X=6135 $Y=61740
X319 38 M4_M5_CDNS_7833375749217 $T=392385 82675 0 0 $X=391860 $Y=82130
X320 41 M4_M5_CDNS_7833375749217 $T=399575 84105 0 0 $X=399050 $Y=83560
X321 38 M3_M4_CDNS_7833375749218 $T=392385 82675 0 0 $X=391860 $Y=82130
X322 41 M3_M4_CDNS_7833375749218 $T=399575 84105 0 0 $X=399050 $Y=83560
X323 38 M2_M3_CDNS_7833375749219 $T=392385 82675 0 0 $X=391860 $Y=82130
X324 41 M2_M3_CDNS_7833375749219 $T=399575 84105 0 0 $X=399050 $Y=83560
X325 41 M1_M2_CDNS_7833375749220 $T=400085 108405 0 0 $X=399280 $Y=108270
X326 46 47 48 49 50 pmos1v2hvt_4_CDNS_783337574920 $T=119265 106555 0 180 $X=116645 $Y=96155
X327 46 51 52 49 50 pmos1v2hvt_4_CDNS_783337574920 $T=171105 106555 0 180 $X=168485 $Y=96155
X328 46 53 54 49 50 pmos1v2hvt_4_CDNS_783337574920 $T=177585 106555 0 180 $X=174965 $Y=96155
X329 46 55 56 49 50 pmos1v2hvt_4_CDNS_783337574920 $T=184065 106555 0 180 $X=181445 $Y=96155
X330 46 57 58 49 50 pmos1v2hvt_4_CDNS_783337574920 $T=190545 106555 0 180 $X=187925 $Y=96155
X331 46 59 60 49 50 pmos1v2hvt_4_CDNS_783337574920 $T=222945 106555 0 180 $X=220325 $Y=96155
X332 46 61 62 49 50 pmos1v2hvt_4_CDNS_783337574920 $T=229425 106555 0 180 $X=226805 $Y=96155
X333 46 63 64 49 50 pmos1v2hvt_4_CDNS_783337574920 $T=235905 106555 0 180 $X=233285 $Y=96155
X334 46 65 66 49 50 pmos1v2hvt_4_CDNS_783337574920 $T=242385 106555 0 180 $X=239765 $Y=96155
X335 46 67 68 49 50 pmos1v2hvt_4_CDNS_783337574920 $T=248865 106555 0 180 $X=246245 $Y=96155
X336 46 69 70 49 50 pmos1v2hvt_4_CDNS_783337574920 $T=281265 106555 0 180 $X=278645 $Y=96155
X337 46 71 72 49 50 pmos1v2hvt_4_CDNS_783337574920 $T=287745 106555 0 180 $X=285125 $Y=96155
X338 46 73 74 49 50 pmos1v2hvt_4_CDNS_783337574920 $T=294225 106555 0 180 $X=291605 $Y=96155
X339 46 75 76 49 50 pmos1v2hvt_4_CDNS_783337574920 $T=300705 106555 0 180 $X=298085 $Y=96155
X340 46 77 78 49 50 pmos1v2hvt_4_CDNS_783337574920 $T=307185 106555 0 180 $X=304565 $Y=96155
X341 46 79 80 49 50 pmos1v2hvt_4_CDNS_783337574920 $T=329865 106555 0 180 $X=327245 $Y=96155
X342 46 81 82 49 50 pmos1v2hvt_4_CDNS_783337574920 $T=336345 106555 0 180 $X=333725 $Y=96155
X343 46 83 84 49 50 pmos1v2hvt_4_CDNS_783337574920 $T=342825 106555 0 180 $X=340205 $Y=96155
X344 46 85 86 49 50 pmos1v2hvt_4_CDNS_783337574920 $T=349305 106555 0 180 $X=346685 $Y=96155
X345 46 87 88 49 50 pmos1v2hvt_4_CDNS_783337574920 $T=355785 106555 0 180 $X=353165 $Y=96155
X346 89 49 50 pmos1v2hvt_4_CDNS_783337574925 $T=103985 118675 1 0 $X=103365 $Y=108275
X347 16 50 50 17 nmos1v2hvt_4_CDNS_783337574928 $T=5090 25990 0 0 $X=4470 $Y=25270
X348 17 50 50 18 nmos1v2hvt_4_CDNS_783337574928 $T=6830 25990 0 0 $X=6210 $Y=25270
X349 17 50 50 42 nmos1v2hvt_4_CDNS_783337574928 $T=9600 25990 0 0 $X=8980 $Y=25270
X350 18 42 50 43 nmos1v2hvt_4_CDNS_783337574928 $T=12075 25990 0 0 $X=11455 $Y=25270
X351 17 50 50 19 nmos1v2hvt_4_CDNS_783337574928 $T=129135 6610 0 0 $X=128515 $Y=5890
X352 16 49 17 50 pmos1v2hvt_4_CDNS_7833375749211 $T=5090 30950 1 0 $X=4470 $Y=28550
X353 18 49 45 50 pmos1v2hvt_4_CDNS_7833375749211 $T=6135 60865 0 270 $X=5415 $Y=59745
X354 18 49 41 50 pmos1v2hvt_4_CDNS_7833375749211 $T=6135 62605 0 270 $X=5415 $Y=61485
X355 17 49 18 50 pmos1v2hvt_4_CDNS_7833375749211 $T=6830 30950 1 0 $X=6210 $Y=28550
X356 30 31 50 rnpolym_CDNS_7833375749213 $T=318935 45040 0 180 $X=317435 $Y=9300
X357 90 50 rnpolym_CDNS_7833375749215 $T=317685 46440 0 0 $X=317435 $Y=45700
X358 30 29 50 rnpolym_CDNS_7833375749216 $T=316935 45040 1 0 $X=316685 $Y=9300
X359 28 90 50 rnpolym_CDNS_7833375749216 $T=316935 81440 1 0 $X=316685 $Y=45700
X360 31 32 50 rnpolym_CDNS_7833375749217 $T=321935 45040 0 180 $X=318935 $Y=9300
X361 33 32 50 rnpolym_CDNS_7833375749218 $T=322185 10040 0 0 $X=321935 $Y=9300
X362 34 33 50 rnpolym_CDNS_7833375749218 $T=322935 45040 1 0 $X=322685 $Y=9300
X363 35 34 50 rnpolym_CDNS_7833375749218 $T=323685 10040 0 0 $X=323435 $Y=9300
X364 36 35 50 rnpolym_CDNS_7833375749218 $T=324435 45040 1 0 $X=324185 $Y=9300
X365 39 36 50 rnpolym_CDNS_7833375749218 $T=325185 10040 0 0 $X=324935 $Y=9300
X366 37 39 50 rnpolym_CDNS_7833375749218 $T=325935 45040 1 0 $X=325685 $Y=9300
X367 40 37 50 rnpolym_CDNS_7833375749218 $T=326685 10040 0 0 $X=326435 $Y=9300
X368 38 40 50 rnpolym_CDNS_7833375749218 $T=327435 45040 1 0 $X=327185 $Y=9300
X369 5 49 6 7 31 32 36 91 9 49
+ 49 38 49 49 49 49 49 49 50 mux8_1p_fL $T=349200 26030 0 90 $X=337860 $Y=26235
X370 15 49 14 13 33 34 35 92 12 11
+ 10 36 39 37 8 93 40 30 50 mux8_1p_fL $T=350670 58455 0 90 $X=339330 $Y=58660
X371 50 21 20 23 25 27 29 trim_res_array_rn_2_fL $T=164075 2440 0 0 $X=169525 $Y=8585
X372 50 22 20 24 26 94 28 trim_res_array_rn_2_fL $T=164075 89040 1 0 $X=169525 $Y=45700
X373 95 96 50 26 24 1 97 98 22 20
+ 99 100 21 23 101 102 25 27 mux8_1_fL $T=154225 55155 0 270 $X=154225 $Y=35725
X374 46 89 49 50 pmos1v2hvt_4_CDNS_7833375749225 $T=107545 106555 1 0 $X=106925 $Y=96155
X375 5 49 50 103 104 7 105 6 9 106
+ 50 107 50 108 50 109 110 50 inv8_fL $T=337805 19250 0 0 $X=337860 $Y=19335
X376 15 49 50 111 112 13 113 14 12 114
+ 115 11 116 8 117 10 93 118 inv8_fL $T=349595 50385 1 180 $X=339490 $Y=50470
X377 45 49 41 50 pmos1v2hvt_4_CDNS_7833375749227 $T=8900 67170 0 0 $X=8280 $Y=66450
X378 45 49 45 50 pmos1v2hvt_4_CDNS_7833375749227 $T=8900 118675 1 0 $X=8280 $Y=93275
X379 45 49 45 50 pmos1v2hvt_4_CDNS_7833375749227 $T=20140 67170 0 0 $X=19520 $Y=66450
X380 45 49 41 50 pmos1v2hvt_4_CDNS_7833375749227 $T=20140 118675 1 0 $X=19520 $Y=93275
X381 45 49 41 50 pmos1v2hvt_4_CDNS_7833375749227 $T=31380 67170 0 0 $X=30760 $Y=66450
X382 45 49 45 50 pmos1v2hvt_4_CDNS_7833375749227 $T=31380 118675 1 0 $X=30760 $Y=93275
X383 45 49 45 50 pmos1v2hvt_4_CDNS_7833375749227 $T=42620 67170 0 0 $X=42000 $Y=66450
X384 45 49 41 50 pmos1v2hvt_4_CDNS_7833375749227 $T=42620 118675 1 0 $X=42000 $Y=93275
X385 45 49 45 50 pmos1v2hvt_4_CDNS_7833375749227 $T=63860 67170 1 180 $X=53240 $Y=66450
X386 45 49 41 50 pmos1v2hvt_4_CDNS_7833375749227 $T=63860 118675 0 180 $X=53240 $Y=93275
X387 45 49 41 50 pmos1v2hvt_4_CDNS_7833375749227 $T=75100 67170 1 180 $X=64480 $Y=66450
X388 45 49 45 50 pmos1v2hvt_4_CDNS_7833375749227 $T=75100 118675 0 180 $X=64480 $Y=93275
X389 45 49 45 50 pmos1v2hvt_4_CDNS_7833375749227 $T=86340 67170 1 180 $X=75720 $Y=66450
X390 45 49 41 50 pmos1v2hvt_4_CDNS_7833375749227 $T=86340 118675 0 180 $X=75720 $Y=93275
X391 45 49 41 50 pmos1v2hvt_4_CDNS_7833375749227 $T=97580 67170 1 180 $X=86960 $Y=66450
X392 45 49 45 50 pmos1v2hvt_4_CDNS_7833375749227 $T=97580 118675 0 180 $X=86960 $Y=93275
X393 50 rnpolym_CDNS_7833375749232 $T=328185 10040 0 0 $X=327935 $Y=9300
X394 42 50 44 nmos1v2hvt_4_CDNS_7833375749233 $T=5090 6850 0 0 $X=4470 $Y=6130
X395 42 50 42 nmos1v2hvt_4_CDNS_7833375749233 $T=5090 24100 1 0 $X=4470 $Y=15700
X396 42 50 42 nmos1v2hvt_4_CDNS_7833375749233 $T=10330 6850 0 0 $X=9710 $Y=6130
X397 42 50 44 nmos1v2hvt_4_CDNS_7833375749233 $T=10330 24100 1 0 $X=9710 $Y=15700
X398 19 50 119 nmos1v2hvt_4_CDNS_7833375749233 $T=134790 6850 0 0 $X=134170 $Y=6130
X399 19 50 19 nmos1v2hvt_4_CDNS_7833375749233 $T=134790 24100 1 0 $X=134170 $Y=15700
X400 19 50 19 nmos1v2hvt_4_CDNS_7833375749233 $T=140030 6850 0 0 $X=139410 $Y=6130
X401 19 50 119 nmos1v2hvt_4_CDNS_7833375749233 $T=140030 24100 1 0 $X=139410 $Y=15700
X402 49 50 pmos1v2hvt_4_CDNS_7833375749242 $T=5660 67170 0 0 $X=5040 $Y=66450
X403 49 50 pmos1v2hvt_4_CDNS_7833375749242 $T=5660 118675 1 0 $X=5040 $Y=93275
X404 49 50 pmos1v2hvt_4_CDNS_7833375749242 $T=98820 67170 0 0 $X=98200 $Y=66450
X405 49 50 pmos1v2hvt_4_CDNS_7833375749242 $T=98820 118675 1 0 $X=98200 $Y=93275
X406 3 19 50 3 nmos1v2hvt_4_CDNS_7833375749243 $T=134790 26535 0 0 $X=134170 $Y=25815
X407 4 3 50 4 nmos1v2hvt_4_CDNS_7833375749243 $T=134790 37020 0 0 $X=134170 $Y=36300
X408 3 119 50 46 nmos1v2hvt_4_CDNS_7833375749243 $T=144370 26535 0 0 $X=143750 $Y=25815
X409 50 rnpolym_CDNS_7833375749246 $T=169025 10040 0 0 $X=168775 $Y=9300
X410 50 rnpolym_CDNS_7833375749246 $T=169025 46440 0 0 $X=168775 $Y=45700
X411 50 rnpolym_CDNS_7833375749246 $T=334185 10040 0 0 $X=333935 $Y=9300
X412 50 rnpolym_CDNS_7833375749246 $T=334185 46440 0 0 $X=333935 $Y=45700
X413 46 120 121 49 50 pmos1v2hvt_4_CDNS_7833375749247 $T=132565 106555 1 0 $X=131945 $Y=96145
X414 46 122 123 49 50 pmos1v2hvt_4_CDNS_7833375749247 $T=148765 106555 1 0 $X=148145 $Y=96145
X415 46 124 125 49 50 pmos1v2hvt_4_CDNS_7833375749250 $T=164625 106555 0 180 $X=162005 $Y=96155
X416 46 126 127 49 50 pmos1v2hvt_4_CDNS_7833375749252 $T=197365 106555 1 0 $X=196745 $Y=96145
X417 46 128 129 49 50 pmos1v2hvt_4_CDNS_7833375749252 $T=260010 106555 1 0 $X=259390 $Y=96145
X418 46 130 131 49 50 pmos1v2hvt_4_CDNS_7833375749252 $T=314365 106555 1 0 $X=313745 $Y=96145
X419 46 132 133 49 50 pmos1v2hvt_4_CDNS_7833375749252 $T=362605 106555 1 0 $X=361985 $Y=96145
X420 46 134 135 49 50 pmos1v2hvt_4_CDNS_7833375749252 $T=378805 106555 1 0 $X=378185 $Y=96145
X421 1 50 50 45 44 50 50 MASCO__A2 $T=122745 36455 0 0 $X=122745 $Y=36455
X422 2 50 50 44 41 44 50 50 MASCO__A3 $T=122745 14935 0 0 $X=122745 $Y=14935
X423 41 41 49 38 49 38 38 49 50 MASCO__A4 $T=392045 108275 0 0 $X=392045 $Y=108275
X424 50 1 50 44 45 2 41 50 50 MASCO__A5 $T=19065 36455 0 0 $X=19065 $Y=36455
X425 2 1 50 44 45 2 41 41 44 MASCO__A5 $T=32025 36455 0 0 $X=32025 $Y=36455
X426 2 1 50 44 45 2 41 41 44 MASCO__A5 $T=44985 36455 0 0 $X=44985 $Y=36455
X427 2 1 50 44 45 2 41 41 44 MASCO__A5 $T=57945 36455 0 0 $X=57945 $Y=36455
X428 2 2 50 44 41 1 45 41 44 MASCO__A5 $T=70905 36455 0 0 $X=70905 $Y=36455
X429 1 2 50 44 41 1 45 45 44 MASCO__A5 $T=83865 36455 0 0 $X=83865 $Y=36455
X430 1 2 50 44 41 1 45 45 44 MASCO__A5 $T=96825 36455 0 0 $X=96825 $Y=36455
X431 1 2 50 44 41 1 45 45 44 MASCO__A5 $T=109785 36455 0 0 $X=109785 $Y=36455
X432 50 2 50 44 41 1 45 50 50 MASCO__A6 $T=19065 14935 0 0 $X=19065 $Y=14935
X433 1 2 50 44 41 1 45 45 44 MASCO__A6 $T=32025 14935 0 0 $X=32025 $Y=14935
X434 1 2 50 44 41 1 45 45 44 MASCO__A6 $T=44985 14935 0 0 $X=44985 $Y=14935
X435 1 2 50 44 41 1 45 45 44 MASCO__A6 $T=57945 14935 0 0 $X=57945 $Y=14935
X436 1 1 50 44 45 2 41 45 44 MASCO__A6 $T=70905 14935 0 0 $X=70905 $Y=14935
X437 2 1 50 44 45 2 41 41 44 MASCO__A6 $T=83865 14935 0 0 $X=83865 $Y=14935
X438 2 1 50 44 45 2 41 41 44 MASCO__A6 $T=96825 14935 0 0 $X=96825 $Y=14935
X439 2 1 50 44 45 2 41 41 44 MASCO__A6 $T=109785 14935 0 0 $X=109785 $Y=14935
X440 41 49 49 38 4 47 38 38 38 120
+ 49 50 MASCO__A7 $T=106925 108275 0 0 $X=106925 $Y=108275
X441 41 41 49 120 120 38 122 122 122 122
+ 120 50 MASCO__A7 $T=132845 108275 0 0 $X=132845 $Y=108275
X442 41 41 49 124 38 51 38 53 38 55
+ 38 50 MASCO__A7 $T=158765 108275 0 0 $X=158765 $Y=108275
X443 41 41 49 57 38 126 38 126 38 126
+ 38 50 MASCO__A7 $T=184685 108275 0 0 $X=184685 $Y=108275
X444 41 41 49 126 38 59 38 61 38 63
+ 38 50 MASCO__A7 $T=210605 108275 0 0 $X=210605 $Y=108275
X445 41 41 49 65 38 67 38 128 38 128
+ 38 50 MASCO__A7 $T=236525 108275 0 0 $X=236525 $Y=108275
X446 41 41 49 128 38 128 38 69 38 71
+ 38 50 MASCO__A7 $T=262445 108275 0 0 $X=262445 $Y=108275
X447 41 41 49 73 38 75 38 77 38 130
+ 38 50 MASCO__A7 $T=288365 108275 0 0 $X=288365 $Y=108275
X448 41 41 49 130 130 38 79 38 81 38
+ 130 50 MASCO__A7 $T=314285 108275 0 0 $X=314285 $Y=108275
X449 41 41 49 38 85 38 87 38 132 132
+ 83 50 MASCO__A7 $T=340205 108275 0 0 $X=340205 $Y=108275
X450 41 41 49 132 38 134 134 134 134 38
+ 132 50 MASCO__A7 $T=366125 108275 0 0 $X=366125 $Y=108275
C0 41 38 8.952e-13 L=3e-05 W=3e-05 m=1 $A=9e-10 $P=0.00012 $[cmims2] $X=366890 $Y=20105 $dt=0
C1 41 38 8.952e-13 L=3e-05 W=3e-05 m=1 $A=9e-10 $P=0.00012 $[cmims2] $X=366890 $Y=52105 $dt=0
C2 41 38 8.952e-13 L=3e-05 W=3e-05 m=1 $A=9e-10 $P=0.00012 $[cmims2] $X=398890 $Y=20105 $dt=0
C3 41 38 8.952e-13 L=3e-05 W=3e-05 m=1 $A=9e-10 $P=0.00012 $[cmims2] $X=398890 $Y=52105 $dt=0
C4 41 38 8.952e-13 L=3e-05 W=3e-05 m=1 $A=9e-10 $P=0.00012 $[cmims2] $X=430890 $Y=20105 $dt=0
C5 41 38 8.952e-13 L=3e-05 W=3e-05 m=1 $A=9e-10 $P=0.00012 $[cmims2] $X=430890 $Y=52105 $dt=0
.ends REF_V5_fL
