* +++++++++++++++++++++++++++++++++++++++++++++++++++++++++ *
* CDL Netlist:                                              *
*                                                           *
* Cell Name  : REF_V5_fL                                    *
* Netlisted  : Mon Jul  6 11:32:59 2026                     *
* PVS Version: 24.11-s045 Mon Jan 27 22:18:54 PST 2025      *
* +++++++++++++++++++++++++++++++++++++++++++++++++++++++++ *
*.LDD
*.DEVTMPLT 0 C(cmims2) CMIMS2 TOPMIMS2(POS) METAL5a(NEG)
*.DEVTMPLT 1 MN(nmos1v2hvt) NMOS1V2HVT NDIFF(D) NGATE(G) NDIFF(S) PW1V2(B)
*.DEVTMPLT 2 MP(pmos1v2hvt) PMOS1V2HVT PDIFF(D) PGATE(G) PDIFF(S) NW1V2(B)
*.DEVTMPLT 3 R(rnpolym) RNPOLYMNW1V2 POLYG3(POS) POLYG3(NEG) NW1V2(SUB)

* +++++++++++++++++++++++++++++++++++++++++++++++++++++++++ *
* Sub cell: pmos1v2hvt_4_CDNS_783337574920                  *
* +++++++++++++++++++++++++++++++++++++++++++++++++++++++++ *
.subckt pmos1v2hvt_4_CDNS_783337574920 1 2 3 4
** N=5 EP=4 FDC=1
M0 3 1 2 4 pmos1v2hvt L=2e-06 W=1e-05 AD=3e-12 AS=3e-12 PD=1.06e-05 PS=1.06e-05 m=1 $X=0 $Y=0 $dt=2
.ends pmos1v2hvt_4_CDNS_783337574920

* +++++++++++++++++++++++++++++++++++++++++++++++++++++++++ *
* Sub cell: pmos1v2hvt_4_CDNS_783337574925                  *
* +++++++++++++++++++++++++++++++++++++++++++++++++++++++++ *
.subckt pmos1v2hvt_4_CDNS_783337574925 1 2
** N=3 EP=2 FDC=1
M0 1 1 2 2 pmos1v2hvt L=5e-07 W=1e-05 AD=3e-12 AS=3e-12 PD=1.06e-05 PS=1.06e-05 m=1 $X=0 $Y=0 $dt=2
.ends pmos1v2hvt_4_CDNS_783337574925

* +++++++++++++++++++++++++++++++++++++++++++++++++++++++++ *
* Sub cell: nmos1v2hvt_4_CDNS_783337574928                  *
* +++++++++++++++++++++++++++++++++++++++++++++++++++++++++ *
.subckt nmos1v2hvt_4_CDNS_783337574928 1 2 3 4
** N=4 EP=4 FDC=1
M0 4 1 2 3 nmos1v2hvt L=5e-07 W=1e-06 AD=3e-13 AS=3e-13 PD=1.6e-06 PS=1.6e-06 m=1 $X=0 $Y=0 $dt=1
.ends nmos1v2hvt_4_CDNS_783337574928

* +++++++++++++++++++++++++++++++++++++++++++++++++++++++++ *
* Sub cell: pmos1v2hvt_4_CDNS_7833375749211                 *
* +++++++++++++++++++++++++++++++++++++++++++++++++++++++++ *
.subckt pmos1v2hvt_4_CDNS_7833375749211 1 2 3
** N=4 EP=3 FDC=1
M0 3 1 2 2 pmos1v2hvt L=5e-07 W=2e-06 AD=6e-13 AS=6e-13 PD=2.6e-06 PS=2.6e-06 m=1 $X=0 $Y=0 $dt=2
.ends pmos1v2hvt_4_CDNS_7833375749211

* +++++++++++++++++++++++++++++++++++++++++++++++++++++++++ *
* Sub cell: rnpolym_CDNS_7833375749213                      *
* +++++++++++++++++++++++++++++++++++++++++++++++++++++++++ *
.subckt rnpolym_CDNS_7833375749213 1 2 3
** N=4 EP=3 FDC=2
R0 2 4 16727.1 L=3.5e-05 W=5e-07 $[rnpolym] $SUB=3 $X=0 $Y=0 $dt=3
R1 1 4 16727.1 L=3.5e-05 W=5e-07 $[rnpolym] $SUB=3 $X=750 $Y=0 $dt=3
.ends rnpolym_CDNS_7833375749213

* +++++++++++++++++++++++++++++++++++++++++++++++++++++++++ *
* Sub cell: rnpolym_CDNS_7833375749215                      *
* +++++++++++++++++++++++++++++++++++++++++++++++++++++++++ *
.subckt rnpolym_CDNS_7833375749215 1 2
** N=23 EP=2 FDC=22
R0 1 3 16727.1 L=3.5e-05 W=5e-07 $[rnpolym] $SUB=2 $X=0 $Y=0 $dt=3
R1 4 3 16727.1 L=3.5e-05 W=5e-07 $[rnpolym] $SUB=2 $X=750 $Y=0 $dt=3
R2 4 5 16727.1 L=3.5e-05 W=5e-07 $[rnpolym] $SUB=2 $X=1500 $Y=0 $dt=3
R3 6 5 16727.1 L=3.5e-05 W=5e-07 $[rnpolym] $SUB=2 $X=2250 $Y=0 $dt=3
R4 6 7 16727.1 L=3.5e-05 W=5e-07 $[rnpolym] $SUB=2 $X=3000 $Y=0 $dt=3
R5 8 7 16727.1 L=3.5e-05 W=5e-07 $[rnpolym] $SUB=2 $X=3750 $Y=0 $dt=3
R6 8 9 16727.1 L=3.5e-05 W=5e-07 $[rnpolym] $SUB=2 $X=4500 $Y=0 $dt=3
R7 10 9 16727.1 L=3.5e-05 W=5e-07 $[rnpolym] $SUB=2 $X=5250 $Y=0 $dt=3
R8 10 11 16727.1 L=3.5e-05 W=5e-07 $[rnpolym] $SUB=2 $X=6000 $Y=0 $dt=3
R9 12 11 16727.1 L=3.5e-05 W=5e-07 $[rnpolym] $SUB=2 $X=6750 $Y=0 $dt=3
R10 12 13 16727.1 L=3.5e-05 W=5e-07 $[rnpolym] $SUB=2 $X=7500 $Y=0 $dt=3
R11 14 13 16727.1 L=3.5e-05 W=5e-07 $[rnpolym] $SUB=2 $X=8250 $Y=0 $dt=3
R12 14 15 16727.1 L=3.5e-05 W=5e-07 $[rnpolym] $SUB=2 $X=9000 $Y=0 $dt=3
R13 16 15 16727.1 L=3.5e-05 W=5e-07 $[rnpolym] $SUB=2 $X=9750 $Y=0 $dt=3
R14 16 17 16727.1 L=3.5e-05 W=5e-07 $[rnpolym] $SUB=2 $X=10500 $Y=0 $dt=3
R15 18 17 16727.1 L=3.5e-05 W=5e-07 $[rnpolym] $SUB=2 $X=11250 $Y=0 $dt=3
R16 18 19 16727.1 L=3.5e-05 W=5e-07 $[rnpolym] $SUB=2 $X=12000 $Y=0 $dt=3
R17 20 19 16727.1 L=3.5e-05 W=5e-07 $[rnpolym] $SUB=2 $X=12750 $Y=0 $dt=3
R18 20 21 16727.1 L=3.5e-05 W=5e-07 $[rnpolym] $SUB=2 $X=13500 $Y=0 $dt=3
R19 22 21 16727.1 L=3.5e-05 W=5e-07 $[rnpolym] $SUB=2 $X=14250 $Y=0 $dt=3
R20 22 23 16727.1 L=3.5e-05 W=5e-07 $[rnpolym] $SUB=2 $X=15000 $Y=0 $dt=3
R21 2 23 16727.1 L=3.5e-05 W=5e-07 $[rnpolym] $SUB=2 $X=15750 $Y=0 $dt=3
.ends rnpolym_CDNS_7833375749215

* +++++++++++++++++++++++++++++++++++++++++++++++++++++++++ *
* Sub cell: rnpolym_CDNS_7833375749216                      *
* +++++++++++++++++++++++++++++++++++++++++++++++++++++++++ *
.subckt rnpolym_CDNS_7833375749216 1 2 3
** N=3 EP=3 FDC=1
R0 1 2 16727.1 L=3.5e-05 W=5e-07 $[rnpolym] $SUB=3 $X=0 $Y=0 $dt=3
.ends rnpolym_CDNS_7833375749216

* +++++++++++++++++++++++++++++++++++++++++++++++++++++++++ *
* Sub cell: rnpolym_CDNS_7833375749217                      *
* +++++++++++++++++++++++++++++++++++++++++++++++++++++++++ *
.subckt rnpolym_CDNS_7833375749217 1 2 3
** N=6 EP=3 FDC=4
R0 2 4 16727.1 L=3.5e-05 W=5e-07 $[rnpolym] $SUB=3 $X=0 $Y=0 $dt=3
R1 5 4 16727.1 L=3.5e-05 W=5e-07 $[rnpolym] $SUB=3 $X=750 $Y=0 $dt=3
R2 5 6 16727.1 L=3.5e-05 W=5e-07 $[rnpolym] $SUB=3 $X=1500 $Y=0 $dt=3
R3 1 6 16727.1 L=3.5e-05 W=5e-07 $[rnpolym] $SUB=3 $X=2250 $Y=0 $dt=3
.ends rnpolym_CDNS_7833375749217

* +++++++++++++++++++++++++++++++++++++++++++++++++++++++++ *
* Sub cell: rnpolym_CDNS_7833375749218                      *
* +++++++++++++++++++++++++++++++++++++++++++++++++++++++++ *
.subckt rnpolym_CDNS_7833375749218 1 2 3
** N=3 EP=3 FDC=1
R0 1 2 16727.1 L=3.5e-05 W=5e-07 $[rnpolym] $SUB=3 $X=0 $Y=0 $dt=3
.ends rnpolym_CDNS_7833375749218

* +++++++++++++++++++++++++++++++++++++++++++++++++++++++++ *
* Sub cell: pmos1v2hvt_4_CDNS_7833375749219                 *
* +++++++++++++++++++++++++++++++++++++++++++++++++++++++++ *
.subckt pmos1v2hvt_4_CDNS_7833375749219 1 2 3 4
** N=5 EP=4 FDC=1
M0 3 1 2 4 pmos1v2hvt L=1e-06 W=1e-05 AD=3e-12 AS=3e-12 PD=1.06e-05 PS=1.06e-05 m=1 $X=0 $Y=0 $dt=2
.ends pmos1v2hvt_4_CDNS_7833375749219

* +++++++++++++++++++++++++++++++++++++++++++++++++++++++++ *
* Sub cell: mux8_1p_fL                                      *
* +++++++++++++++++++++++++++++++++++++++++++++++++++++++++ *
.subckt mux8_1p_fL A0 VDDA A1 A2 IN0 IN1 IN2 COM A3 A4
+ A5 IN3 IN4 IN5 A6 A7 IN6 IN7
** N=19 EP=18 FDC=8
X0 A0 IN0 COM VDDA pmos1v2hvt_4_CDNS_7833375749219 $T=825 940 0 0 $X=205 $Y=220
X1 A1 IN1 COM VDDA pmos1v2hvt_4_CDNS_7833375749219 $T=3065 940 0 0 $X=2445 $Y=220
X2 A2 IN2 COM VDDA pmos1v2hvt_4_CDNS_7833375749219 $T=5305 940 0 0 $X=4685 $Y=220
X3 A3 IN3 COM VDDA pmos1v2hvt_4_CDNS_7833375749219 $T=7545 940 0 0 $X=6925 $Y=220
X4 A4 IN4 COM VDDA pmos1v2hvt_4_CDNS_7833375749219 $T=9785 940 0 0 $X=9165 $Y=220
X5 A5 IN5 COM VDDA pmos1v2hvt_4_CDNS_7833375749219 $T=12025 940 0 0 $X=11405 $Y=220
X6 A6 IN6 COM VDDA pmos1v2hvt_4_CDNS_7833375749219 $T=14265 940 0 0 $X=13645 $Y=220
X7 A7 IN7 COM VDDA pmos1v2hvt_4_CDNS_7833375749219 $T=16505 940 0 0 $X=15885 $Y=220
.ends mux8_1p_fL

* +++++++++++++++++++++++++++++++++++++++++++++++++++++++++ *
* Sub cell: trim_res_rnpolyn_2_fL                           *
* +++++++++++++++++++++++++++++++++++++++++++++++++++++++++ *
.subckt trim_res_rnpolyn_2_fL P1 P2 GNDA
** N=4 EP=3 FDC=14
X24 P1 4 GNDA rnpolym_CDNS_7833375749216 $T=9255 745 0 0 $X=9005 $Y=5
X25 4 P2 GNDA rnpolym_CDNS_7833375749216 $T=10005 35745 1 0 $X=9755 $Y=5
R0 P1 P2 16727.1 L=3.5e-05 W=5e-07 $[rnpolym] $SUB=GNDA $X=255 $Y=745 $dt=3
R1 P1 P2 16727.1 L=3.5e-05 W=5e-07 $[rnpolym] $SUB=GNDA $X=1005 $Y=745 $dt=3
R2 P1 P2 16727.1 L=3.5e-05 W=5e-07 $[rnpolym] $SUB=GNDA $X=1755 $Y=745 $dt=3
R3 P1 P2 16727.1 L=3.5e-05 W=5e-07 $[rnpolym] $SUB=GNDA $X=2505 $Y=745 $dt=3
R4 P1 P2 16727.1 L=3.5e-05 W=5e-07 $[rnpolym] $SUB=GNDA $X=3255 $Y=745 $dt=3
R5 P1 P2 16727.1 L=3.5e-05 W=5e-07 $[rnpolym] $SUB=GNDA $X=4005 $Y=745 $dt=3
R6 P1 P2 16727.1 L=3.5e-05 W=5e-07 $[rnpolym] $SUB=GNDA $X=4755 $Y=745 $dt=3
R7 P1 P2 16727.1 L=3.5e-05 W=5e-07 $[rnpolym] $SUB=GNDA $X=5505 $Y=745 $dt=3
R8 P1 P2 16727.1 L=3.5e-05 W=5e-07 $[rnpolym] $SUB=GNDA $X=6255 $Y=745 $dt=3
R9 P1 P2 16727.1 L=3.5e-05 W=5e-07 $[rnpolym] $SUB=GNDA $X=7005 $Y=745 $dt=3
R10 P1 P2 16727.1 L=3.5e-05 W=5e-07 $[rnpolym] $SUB=GNDA $X=7755 $Y=745 $dt=3
R11 P1 P2 16727.1 L=3.5e-05 W=5e-07 $[rnpolym] $SUB=GNDA $X=8505 $Y=745 $dt=3
.ends trim_res_rnpolyn_2_fL

* +++++++++++++++++++++++++++++++++++++++++++++++++++++++++ *
* Sub cell: trim_res_array_rn_2_fL                          *
* +++++++++++++++++++++++++++++++++++++++++++++++++++++++++ *
.subckt trim_res_array_rn_2_fL GNDA SEL1 P1 SEL2 SEL3 SEL4 P2
** N=15 EP=7 FDC=196
X2 P1 SEL1 GNDA trim_res_rnpolyn_2_fL $T=5445 6855 0 0 $X=5450 $Y=6145
X3 SEL1 SEL2 GNDA trim_res_rnpolyn_2_fL $T=15945 6855 0 0 $X=15950 $Y=6145
X4 SEL2 SEL3 GNDA trim_res_rnpolyn_2_fL $T=26445 6855 0 0 $X=26450 $Y=6145
X5 SEL3 SEL4 GNDA trim_res_rnpolyn_2_fL $T=36945 6855 0 0 $X=36950 $Y=6145
X6 SEL4 9 GNDA trim_res_rnpolyn_2_fL $T=47445 6855 0 0 $X=47450 $Y=6145
X7 9 10 GNDA trim_res_rnpolyn_2_fL $T=57945 6855 0 0 $X=57950 $Y=6145
X8 10 11 GNDA trim_res_rnpolyn_2_fL $T=68445 6855 0 0 $X=68450 $Y=6145
X9 11 12 GNDA trim_res_rnpolyn_2_fL $T=78945 6855 0 0 $X=78950 $Y=6145
X10 12 13 GNDA trim_res_rnpolyn_2_fL $T=89445 6855 0 0 $X=89450 $Y=6145
X11 13 14 GNDA trim_res_rnpolyn_2_fL $T=99945 6855 0 0 $X=99950 $Y=6145
X12 14 15 GNDA trim_res_rnpolyn_2_fL $T=110445 6855 0 0 $X=110450 $Y=6145
X13 15 8 GNDA trim_res_rnpolyn_2_fL $T=120945 6855 0 0 $X=120950 $Y=6145
X14 P2 8 GNDA trim_res_rnpolyn_2_fL $T=142350 6855 1 180 $X=131595 $Y=6145
X15 P2 8 GNDA trim_res_rnpolyn_2_fL $T=142105 6855 0 0 $X=142110 $Y=6145
.ends trim_res_array_rn_2_fL

* +++++++++++++++++++++++++++++++++++++++++++++++++++++++++ *
* Sub cell: nmos1v2hvt_4_CDNS_7833375749223                 *
* +++++++++++++++++++++++++++++++++++++++++++++++++++++++++ *
.subckt nmos1v2hvt_4_CDNS_7833375749223 1 2 3 4
** N=4 EP=4 FDC=1
M0 3 1 2 4 nmos1v2hvt L=1e-06 W=1e-05 AD=3e-12 AS=3e-12 PD=1.06e-05 PS=1.06e-05 m=1 $X=0 $Y=0 $dt=1
.ends nmos1v2hvt_4_CDNS_7833375749223

* +++++++++++++++++++++++++++++++++++++++++++++++++++++++++ *
* Sub cell: mux8_1_fL                                       *
* +++++++++++++++++++++++++++++++++++++++++++++++++++++++++ *
.subckt mux8_1_fL A0 A1 GNDA IN0 IN1 COM A2 A3 IN2 IN3
+ A4 A5 IN4 IN5 A6 A7 IN6 IN7
** N=18 EP=18 FDC=8
X16 A0 COM IN0 GNDA nmos1v2hvt_4_CDNS_7833375749223 $T=1515 1315 0 0 $X=915 $Y=915
X17 A1 COM IN1 GNDA nmos1v2hvt_4_CDNS_7833375749223 $T=3715 1315 0 0 $X=3115 $Y=915
X18 A2 COM IN2 GNDA nmos1v2hvt_4_CDNS_7833375749223 $T=5915 1315 0 0 $X=5315 $Y=915
X19 A3 COM IN3 GNDA nmos1v2hvt_4_CDNS_7833375749223 $T=8115 1315 0 0 $X=7515 $Y=915
X20 A4 COM IN4 GNDA nmos1v2hvt_4_CDNS_7833375749223 $T=10315 1315 0 0 $X=9715 $Y=915
X21 A5 COM IN5 GNDA nmos1v2hvt_4_CDNS_7833375749223 $T=12515 1315 0 0 $X=11915 $Y=915
X22 A6 COM IN6 GNDA nmos1v2hvt_4_CDNS_7833375749223 $T=14715 1315 0 0 $X=14115 $Y=915
X23 A7 COM IN7 GNDA nmos1v2hvt_4_CDNS_7833375749223 $T=16915 1315 0 0 $X=16315 $Y=915
.ends mux8_1_fL

* +++++++++++++++++++++++++++++++++++++++++++++++++++++++++ *
* Sub cell: pmos1v2hvt_4_CDNS_7833375749225                 *
* +++++++++++++++++++++++++++++++++++++++++++++++++++++++++ *
.subckt pmos1v2hvt_4_CDNS_7833375749225 1 2 3
** N=4 EP=3 FDC=1
M0 1 1 2 3 pmos1v2hvt L=1e-06 W=1e-05 AD=3e-12 AS=3e-12 PD=1.06e-05 PS=1.06e-05 m=1 $X=0 $Y=0 $dt=2
.ends pmos1v2hvt_4_CDNS_7833375749225

* +++++++++++++++++++++++++++++++++++++++++++++++++++++++++ *
* Sub cell: IN2                                             *
* +++++++++++++++++++++++++++++++++++++++++++++++++++++++++ *
.subckt IN2 A Out VDD VSS
** N=4 EP=4 FDC=2
M0 Out A VSS VSS nmos1v2hvt L=1.8e-07 W=6e-07 AD=1.8e-13 AS=1.8e-13 PD=1.2e-06 PS=1.2e-06 m=1 $X=375 $Y=390 $dt=1
M1 Out A VDD VDD pmos1v2hvt L=1.8e-07 W=9.4e-07 AD=2.82e-13 AS=2.82e-13 PD=1.54e-06 PS=1.54e-06 m=1 $X=375 $Y=1470 $dt=2
.ends IN2

* +++++++++++++++++++++++++++++++++++++++++++++++++++++++++ *
* Sub cell: inv8_fL                                         *
* +++++++++++++++++++++++++++++++++++++++++++++++++++++++++ *
.subckt inv8_fL OUT0 VDDA GNDA IN0 IN1 OUT2 IN2 OUT1 OUT3 IN3
+ IN5 OUT4 IN4 OUT6 IN6 OUT5 OUT7 IN7
** N=18 EP=18 FDC=16
X0 IN0 OUT0 VDDA GNDA IN2 $T=280 335 0 0 $X=55 $Y=85
X1 IN1 OUT1 VDDA GNDA IN2 $T=1480 335 0 0 $X=1255 $Y=85
X2 IN2 OUT2 VDDA GNDA IN2 $T=2680 335 0 0 $X=2455 $Y=85
X3 IN3 OUT3 VDDA GNDA IN2 $T=3880 335 0 0 $X=3655 $Y=85
X4 IN4 OUT4 VDDA GNDA IN2 $T=5080 335 0 0 $X=4855 $Y=85
X5 IN5 OUT5 VDDA GNDA IN2 $T=6280 335 0 0 $X=6055 $Y=85
X6 IN6 OUT6 VDDA GNDA IN2 $T=7480 335 0 0 $X=7255 $Y=85
X7 IN7 OUT7 VDDA GNDA IN2 $T=8680 335 0 0 $X=8455 $Y=85
.ends inv8_fL

* +++++++++++++++++++++++++++++++++++++++++++++++++++++++++ *
* Sub cell: pmos1v2hvt_4_CDNS_7833375749227                 *
* +++++++++++++++++++++++++++++++++++++++++++++++++++++++++ *
.subckt pmos1v2hvt_4_CDNS_7833375749227 1 2 3
** N=4 EP=3 FDC=1
M0 3 1 2 2 pmos1v2hvt L=1e-05 W=2.5e-05 AD=7.5e-12 AS=7.5e-12 PD=2.56e-05 PS=2.56e-05 m=1 $X=0 $Y=0 $dt=2
.ends pmos1v2hvt_4_CDNS_7833375749227

* +++++++++++++++++++++++++++++++++++++++++++++++++++++++++ *
* Sub cell: rnpolym_CDNS_7833375749232                      *
* +++++++++++++++++++++++++++++++++++++++++++++++++++++++++ *
.subckt rnpolym_CDNS_7833375749232 1
** N=8 EP=1 FDC=8
R0 1 2 16727.1 L=3.5e-05 W=5e-07 $[rnpolym] $SUB=1 $X=0 $Y=0 $dt=3
R1 3 2 16727.1 L=3.5e-05 W=5e-07 $[rnpolym] $SUB=1 $X=750 $Y=0 $dt=3
R2 3 4 16727.1 L=3.5e-05 W=5e-07 $[rnpolym] $SUB=1 $X=1500 $Y=0 $dt=3
R3 5 4 16727.1 L=3.5e-05 W=5e-07 $[rnpolym] $SUB=1 $X=2250 $Y=0 $dt=3
R4 5 6 16727.1 L=3.5e-05 W=5e-07 $[rnpolym] $SUB=1 $X=3000 $Y=0 $dt=3
R5 7 6 16727.1 L=3.5e-05 W=5e-07 $[rnpolym] $SUB=1 $X=3750 $Y=0 $dt=3
R6 7 8 16727.1 L=3.5e-05 W=5e-07 $[rnpolym] $SUB=1 $X=4500 $Y=0 $dt=3
R7 1 8 16727.1 L=3.5e-05 W=5e-07 $[rnpolym] $SUB=1 $X=5250 $Y=0 $dt=3
.ends rnpolym_CDNS_7833375749232

* +++++++++++++++++++++++++++++++++++++++++++++++++++++++++ *
* Sub cell: nmos1v2hvt_4_CDNS_7833375749233                 *
* +++++++++++++++++++++++++++++++++++++++++++++++++++++++++ *
.subckt nmos1v2hvt_4_CDNS_7833375749233 1 2 3
** N=3 EP=3 FDC=1
M0 3 1 2 2 nmos1v2hvt L=4e-06 W=8e-06 AD=2.4e-12 AS=2.4e-12 PD=8.6e-06 PS=8.6e-06 m=1 $X=0 $Y=0 $dt=1
.ends nmos1v2hvt_4_CDNS_7833375749233

* +++++++++++++++++++++++++++++++++++++++++++++++++++++++++ *
* Sub cell: pmos1v2hvt_4_CDNS_7833375749242                 *
* +++++++++++++++++++++++++++++++++++++++++++++++++++++++++ *
.subckt pmos1v2hvt_4_CDNS_7833375749242 1
** N=2 EP=1 FDC=1
M0 1 1 1 1 pmos1v2hvt L=2e-06 W=2.5e-05 AD=7.5e-12 AS=7.5e-12 PD=2.56e-05 PS=2.56e-05 m=1 $X=0 $Y=0 $dt=2
.ends pmos1v2hvt_4_CDNS_7833375749242

* +++++++++++++++++++++++++++++++++++++++++++++++++++++++++ *
* Sub cell: nmos1v2hvt_4_CDNS_7833375749243                 *
* +++++++++++++++++++++++++++++++++++++++++++++++++++++++++ *
.subckt nmos1v2hvt_4_CDNS_7833375749243 1 2 3 4
** N=4 EP=4 FDC=2
M0 4 1 2 3 nmos1v2hvt L=4e-06 W=8e-06 AD=2.72e-12 AS=2.4e-12 PD=8.68e-06 PS=8.6e-06 m=1 $X=0 $Y=0 $dt=1
M1 2 1 4 3 nmos1v2hvt L=4e-06 W=8e-06 AD=2.4e-12 AS=2.72e-12 PD=8.6e-06 PS=8.68e-06 m=1 $X=4340 $Y=0 $dt=1
.ends nmos1v2hvt_4_CDNS_7833375749243

* +++++++++++++++++++++++++++++++++++++++++++++++++++++++++ *
* Sub cell: rnpolym_CDNS_7833375749246                      *
* +++++++++++++++++++++++++++++++++++++++++++++++++++++++++ *
.subckt rnpolym_CDNS_7833375749246 1
** N=1 EP=1 FDC=1
R0 1 1 16727.1 L=3.5e-05 W=5e-07 $[rnpolym] $SUB=1 $X=0 $Y=0 $dt=3
.ends rnpolym_CDNS_7833375749246

* +++++++++++++++++++++++++++++++++++++++++++++++++++++++++ *
* Sub cell: pmos1v2hvt_4_CDNS_7833375749247                 *
* +++++++++++++++++++++++++++++++++++++++++++++++++++++++++ *
.subckt pmos1v2hvt_4_CDNS_7833375749247 1 2 3 4
** N=5 EP=4 FDC=4
M0 3 1 2 4 pmos1v2hvt L=2e-06 W=1e-05 AD=3.4e-12 AS=3e-12 PD=1.068e-05 PS=1.06e-05 m=1 $X=0 $Y=0 $dt=2
M1 2 1 3 4 pmos1v2hvt L=2e-06 W=1e-05 AD=3.4e-12 AS=3.4e-12 PD=1.068e-05 PS=1.068e-05 m=1 $X=2340 $Y=0 $dt=2
M2 3 1 2 4 pmos1v2hvt L=2e-06 W=1e-05 AD=3.4e-12 AS=3.4e-12 PD=1.068e-05 PS=1.068e-05 m=1 $X=4680 $Y=0 $dt=2
M3 2 1 3 4 pmos1v2hvt L=2e-06 W=1e-05 AD=3e-12 AS=3.4e-12 PD=1.06e-05 PS=1.068e-05 m=1 $X=7020 $Y=0 $dt=2
.ends pmos1v2hvt_4_CDNS_7833375749247

* +++++++++++++++++++++++++++++++++++++++++++++++++++++++++ *
* Sub cell: pmos1v2hvt_4_CDNS_7833375749250                 *
* +++++++++++++++++++++++++++++++++++++++++++++++++++++++++ *
.subckt pmos1v2hvt_4_CDNS_7833375749250 1 2 3 4
** N=5 EP=4 FDC=1
M0 3 1 2 4 pmos1v2hvt L=2e-06 W=1e-05 AD=3e-12 AS=3e-12 PD=1.06e-05 PS=1.06e-05 m=1 $X=0 $Y=0 $dt=2
.ends pmos1v2hvt_4_CDNS_7833375749250

* +++++++++++++++++++++++++++++++++++++++++++++++++++++++++ *
* Sub cell: pmos1v2hvt_4_CDNS_7833375749252                 *
* +++++++++++++++++++++++++++++++++++++++++++++++++++++++++ *
.subckt pmos1v2hvt_4_CDNS_7833375749252 1 2 3 4
** N=5 EP=4 FDC=4
M0 3 1 2 4 pmos1v2hvt L=2e-06 W=1e-05 AD=3.4e-12 AS=3e-12 PD=1.068e-05 PS=1.06e-05 m=1 $X=0 $Y=0 $dt=2
M1 2 1 3 4 pmos1v2hvt L=2e-06 W=1e-05 AD=3.4e-12 AS=3.4e-12 PD=1.068e-05 PS=1.068e-05 m=1 $X=2340 $Y=0 $dt=2
M2 3 1 2 4 pmos1v2hvt L=2e-06 W=1e-05 AD=3.4e-12 AS=3.4e-12 PD=1.068e-05 PS=1.068e-05 m=1 $X=4680 $Y=0 $dt=2
M3 2 1 3 4 pmos1v2hvt L=2e-06 W=1e-05 AD=3e-12 AS=3.4e-12 PD=1.06e-05 PS=1.068e-05 m=1 $X=7020 $Y=0 $dt=2
.ends pmos1v2hvt_4_CDNS_7833375749252

* +++++++++++++++++++++++++++++++++++++++++++++++++++++++++ *
* Sub cell: nmos1v2hvt_4_CDNS_7833375749238                 *
* +++++++++++++++++++++++++++++++++++++++++++++++++++++++++ *
.subckt nmos1v2hvt_4_CDNS_7833375749238 1 2 3 4
** N=4 EP=4 FDC=1
M0 3 1 2 4 nmos1v2hvt L=2e-06 W=1.875e-05 AD=5.625e-12 AS=5.625e-12 PD=1.935e-05 PS=1.935e-05 m=1 $X=0 $Y=0 $dt=1
.ends nmos1v2hvt_4_CDNS_7833375749238

* +++++++++++++++++++++++++++++++++++++++++++++++++++++++++ *
* Sub cell: MASCO__A2                                       *
* +++++++++++++++++++++++++++++++++++++++++++++++++++++++++ *
.subckt MASCO__A2 1 2 3 4 5 6 7
** N=7 EP=7 FDC=2
X0 1 5 4 3 nmos1v2hvt_4_CDNS_7833375749238 $T=620 19150 1 0 $X=0 $Y=0
X1 2 7 6 3 nmos1v2hvt_4_CDNS_7833375749238 $T=3860 19150 1 0 $X=3240 $Y=0
.ends MASCO__A2

* +++++++++++++++++++++++++++++++++++++++++++++++++++++++++ *
* Sub cell: MASCO__A3                                       *
* +++++++++++++++++++++++++++++++++++++++++++++++++++++++++ *
.subckt MASCO__A3 1 2 3 5 6 7 8
** N=8 EP=7 FDC=2
X0 1 6 5 3 nmos1v2hvt_4_CDNS_7833375749238 $T=620 720 0 0 $X=0 $Y=0
X1 2 8 7 3 nmos1v2hvt_4_CDNS_7833375749238 $T=3860 720 0 0 $X=3240 $Y=0
.ends MASCO__A3

* +++++++++++++++++++++++++++++++++++++++++++++++++++++++++ *
* Sub cell: MASCO__A1                                       *
* +++++++++++++++++++++++++++++++++++++++++++++++++++++++++ *
.subckt MASCO__A1 1 2 3 4 5
** N=6 EP=5 FDC=2
X0 1 2 3 2 pmos1v2hvt_4_CDNS_783337574920 $T=620 10400 1 0 $X=0 $Y=0
X1 4 2 5 2 pmos1v2hvt_4_CDNS_783337574920 $T=3860 10400 1 0 $X=3240 $Y=0
.ends MASCO__A1

* +++++++++++++++++++++++++++++++++++++++++++++++++++++++++ *
* Sub cell: MASCO__A4                                       *
* +++++++++++++++++++++++++++++++++++++++++++++++++++++++++ *
.subckt MASCO__A4 1 2 3 4 5 6 7 8
** N=9 EP=8 FDC=4
X0 1 3 7 2 4 MASCO__A1 $T=0 0 0 0 $X=0 $Y=0
X1 2 3 6 5 8 MASCO__A1 $T=6480 0 0 0 $X=6480 $Y=0
.ends MASCO__A4

* +++++++++++++++++++++++++++++++++++++++++++++++++++++++++ *
* Sub cell: MASCO__A5                                       *
* +++++++++++++++++++++++++++++++++++++++++++++++++++++++++ *
.subckt MASCO__A5 1 2 3 4 5 6 7 8 9
** N=9 EP=9 FDC=4
X0 1 2 3 8 9 5 4 MASCO__A2 $T=0 0 0 0 $X=0 $Y=0
X1 6 2 3 7 4 5 4 MASCO__A2 $T=6480 0 0 0 $X=6480 $Y=0
.ends MASCO__A5

* +++++++++++++++++++++++++++++++++++++++++++++++++++++++++ *
* Sub cell: MASCO__A6                                       *
* +++++++++++++++++++++++++++++++++++++++++++++++++++++++++ *
.subckt MASCO__A6 1 2 3 4 5 6 7 8 9
** N=9 EP=9 FDC=4
X0 1 2 3 8 9 5 4 MASCO__A3 $T=0 0 0 0 $X=0 $Y=0
X1 6 2 3 7 4 5 4 MASCO__A3 $T=6480 0 0 0 $X=6480 $Y=0
.ends MASCO__A6

* +++++++++++++++++++++++++++++++++++++++++++++++++++++++++ *
* Sub cell: MASCO__A7                                       *
* +++++++++++++++++++++++++++++++++++++++++++++++++++++++++ *
.subckt MASCO__A7 1 2 3 4 5 6 7 8 9 10
+ 11
** N=12 EP=11 FDC=8
X0 2 1 3 4 1 5 11 6 MASCO__A4 $T=0 0 0 0 $X=0 $Y=0
X1 1 1 3 8 1 9 7 10 MASCO__A4 $T=12960 0 0 0 $X=12960 $Y=0
.ends MASCO__A7

* +++++++++++++++++++++++++++++++++++++++++++++++++++++++++ *
* Sub cell: REF_V5_fL                                       *
* +++++++++++++++++++++++++++++++++++++++++++++++++++++++++ *
.subckt REF_V5_fL A0 A1 A2 A3 A4 A5 A6 A7 BG_REF BIAS
+ CJ_G1<0> CJ_G1<1> CJ_G1<2> CJ_G1<3> CJ_G1<4> CJ_G1<5> CJ_G2<0> CJ_G2<1> CJ_G2<2> CJ_G2<3>
+ CJ_G2<4> CJ_G2<5> CJ_G3<0> CJ_G3<1> CJ_G3<2> CJ_G3<3> CJ_G3<4> CJ_G3<5> CJ_G4<0> CJ_G4<1>
+ CJ_G4<2> CJ_G4<3> CJ_G4<4> CJ_G4<5> CL1X_1 CL4X_1 CL4X_2 EN GNDA Ib128nAT
+ LDO_REF LDO_SEL<0> LDO_SEL<1> LDO_SEL<2> LDO_SEL<3> LVDS_REF LVDS_SEL<0> LVDS_SEL<1> LVDS_SEL<2> LVDS_SEL<3>
+ LVDS_SEL<4> LVDS_SEL<5> LVDS_SEL<6> LVDS_SEL<7> V1000 V550 VDDA
** N=135 EP=57 FDC=758
X326 46 47 CL1X_1 VDDA pmos1v2hvt_4_CDNS_783337574920 $T=119265 106555 0 180 $X=116645 $Y=96155
X327 46 51 CJ_G1<1> VDDA pmos1v2hvt_4_CDNS_783337574920 $T=171105 106555 0 180 $X=168485 $Y=96155
X328 46 53 CJ_G1<2> VDDA pmos1v2hvt_4_CDNS_783337574920 $T=177585 106555 0 180 $X=174965 $Y=96155
X329 46 55 CJ_G1<3> VDDA pmos1v2hvt_4_CDNS_783337574920 $T=184065 106555 0 180 $X=181445 $Y=96155
X330 46 57 CJ_G1<4> VDDA pmos1v2hvt_4_CDNS_783337574920 $T=190545 106555 0 180 $X=187925 $Y=96155
X331 46 59 CJ_G2<0> VDDA pmos1v2hvt_4_CDNS_783337574920 $T=222945 106555 0 180 $X=220325 $Y=96155
X332 46 61 CJ_G2<1> VDDA pmos1v2hvt_4_CDNS_783337574920 $T=229425 106555 0 180 $X=226805 $Y=96155
X333 46 63 CJ_G2<2> VDDA pmos1v2hvt_4_CDNS_783337574920 $T=235905 106555 0 180 $X=233285 $Y=96155
X334 46 65 CJ_G2<3> VDDA pmos1v2hvt_4_CDNS_783337574920 $T=242385 106555 0 180 $X=239765 $Y=96155
X335 46 67 CJ_G2<4> VDDA pmos1v2hvt_4_CDNS_783337574920 $T=248865 106555 0 180 $X=246245 $Y=96155
X336 46 69 CJ_G3<0> VDDA pmos1v2hvt_4_CDNS_783337574920 $T=281265 106555 0 180 $X=278645 $Y=96155
X337 46 71 CJ_G3<1> VDDA pmos1v2hvt_4_CDNS_783337574920 $T=287745 106555 0 180 $X=285125 $Y=96155
X338 46 73 CJ_G3<2> VDDA pmos1v2hvt_4_CDNS_783337574920 $T=294225 106555 0 180 $X=291605 $Y=96155
X339 46 75 CJ_G3<3> VDDA pmos1v2hvt_4_CDNS_783337574920 $T=300705 106555 0 180 $X=298085 $Y=96155
X340 46 77 CJ_G3<4> VDDA pmos1v2hvt_4_CDNS_783337574920 $T=307185 106555 0 180 $X=304565 $Y=96155
X341 46 79 CJ_G4<0> VDDA pmos1v2hvt_4_CDNS_783337574920 $T=329865 106555 0 180 $X=327245 $Y=96155
X342 46 81 CJ_G4<1> VDDA pmos1v2hvt_4_CDNS_783337574920 $T=336345 106555 0 180 $X=333725 $Y=96155
X343 46 83 CJ_G4<2> VDDA pmos1v2hvt_4_CDNS_783337574920 $T=342825 106555 0 180 $X=340205 $Y=96155
X344 46 85 CJ_G4<3> VDDA pmos1v2hvt_4_CDNS_783337574920 $T=349305 106555 0 180 $X=346685 $Y=96155
X345 46 87 CJ_G4<4> VDDA pmos1v2hvt_4_CDNS_783337574920 $T=355785 106555 0 180 $X=353165 $Y=96155
X346 89 VDDA pmos1v2hvt_4_CDNS_783337574925 $T=103985 118675 1 0 $X=103365 $Y=108275
X347 EN GNDA GNDA 17 nmos1v2hvt_4_CDNS_783337574928 $T=5090 25990 0 0 $X=4470 $Y=25270
X348 17 GNDA GNDA 18 nmos1v2hvt_4_CDNS_783337574928 $T=6830 25990 0 0 $X=6210 $Y=25270
X349 17 GNDA GNDA 42 nmos1v2hvt_4_CDNS_783337574928 $T=9600 25990 0 0 $X=8980 $Y=25270
X350 18 42 GNDA BIAS nmos1v2hvt_4_CDNS_783337574928 $T=12075 25990 0 0 $X=11455 $Y=25270
X351 17 GNDA GNDA 19 nmos1v2hvt_4_CDNS_783337574928 $T=129135 6610 0 0 $X=128515 $Y=5890
X352 EN VDDA 17 pmos1v2hvt_4_CDNS_7833375749211 $T=5090 30950 1 0 $X=4470 $Y=28550
X353 18 VDDA 45 pmos1v2hvt_4_CDNS_7833375749211 $T=6135 60865 0 270 $X=5415 $Y=59745
X354 18 VDDA 41 pmos1v2hvt_4_CDNS_7833375749211 $T=6135 62605 0 270 $X=5415 $Y=61485
X355 17 VDDA 18 pmos1v2hvt_4_CDNS_7833375749211 $T=6830 30950 1 0 $X=6210 $Y=28550
X356 30 31 GNDA rnpolym_CDNS_7833375749213 $T=318935 45040 0 180 $X=317435 $Y=9300
X357 V550 GNDA rnpolym_CDNS_7833375749215 $T=317685 46440 0 0 $X=317435 $Y=45700
X358 30 29 GNDA rnpolym_CDNS_7833375749216 $T=316935 45040 1 0 $X=316685 $Y=9300
X359 28 V550 GNDA rnpolym_CDNS_7833375749216 $T=316935 81440 1 0 $X=316685 $Y=45700
X360 31 32 GNDA rnpolym_CDNS_7833375749217 $T=321935 45040 0 180 $X=318935 $Y=9300
X361 33 32 GNDA rnpolym_CDNS_7833375749218 $T=322185 10040 0 0 $X=321935 $Y=9300
X362 34 33 GNDA rnpolym_CDNS_7833375749218 $T=322935 45040 1 0 $X=322685 $Y=9300
X363 35 34 GNDA rnpolym_CDNS_7833375749218 $T=323685 10040 0 0 $X=323435 $Y=9300
X364 36 35 GNDA rnpolym_CDNS_7833375749218 $T=324435 45040 1 0 $X=324185 $Y=9300
X365 39 36 GNDA rnpolym_CDNS_7833375749218 $T=325185 10040 0 0 $X=324935 $Y=9300
X366 37 39 GNDA rnpolym_CDNS_7833375749218 $T=325935 45040 1 0 $X=325685 $Y=9300
X367 40 37 GNDA rnpolym_CDNS_7833375749218 $T=326685 10040 0 0 $X=326435 $Y=9300
X368 V1000 40 GNDA rnpolym_CDNS_7833375749218 $T=327435 45040 1 0 $X=327185 $Y=9300
X369 5 VDDA 6 7 31 32 36 LDO_REF 9 VDDA
+ VDDA V1000 VDDA VDDA VDDA VDDA VDDA VDDA mux8_1p_fL $T=349200 26030 0 90 $X=337860 $Y=26235
X370 15 VDDA 14 13 33 34 35 LVDS_REF 12 11
+ 10 36 39 37 8 93 40 30 mux8_1p_fL $T=350670 58455 0 90 $X=339330 $Y=58660
X371 GNDA 21 20 23 25 27 29 trim_res_array_rn_2_fL $T=164075 2440 0 0 $X=169525 $Y=8585
X372 GNDA 22 20 24 26 94 28 trim_res_array_rn_2_fL $T=164075 89040 1 0 $X=169525 $Y=45700
X373 A0 A1 GNDA 26 24 1 A2 A3 22 20
+ A4 A5 21 23 A6 A7 25 27 mux8_1_fL $T=154225 55155 0 270 $X=154225 $Y=35725
X374 46 89 VDDA pmos1v2hvt_4_CDNS_7833375749225 $T=107545 106555 1 0 $X=106925 $Y=96155
X375 5 VDDA GNDA LDO_SEL<0> LDO_SEL<1> 7 LDO_SEL<2> 6 9 LDO_SEL<3>
+ GNDA 107 GNDA 108 GNDA 109 110 GNDA inv8_fL $T=337805 19250 0 0 $X=337860 $Y=19335
X376 15 VDDA GNDA LVDS_SEL<0> LVDS_SEL<1> 13 LVDS_SEL<2> 14 12 LVDS_SEL<3>
+ LVDS_SEL<5> 11 LVDS_SEL<4> 8 LVDS_SEL<6> 10 93 LVDS_SEL<7> inv8_fL $T=349595 50385 1 180 $X=339490 $Y=50470
X377 45 VDDA 41 pmos1v2hvt_4_CDNS_7833375749227 $T=8900 67170 0 0 $X=8280 $Y=66450
X378 45 VDDA 45 pmos1v2hvt_4_CDNS_7833375749227 $T=8900 118675 1 0 $X=8280 $Y=93275
X379 45 VDDA 45 pmos1v2hvt_4_CDNS_7833375749227 $T=20140 67170 0 0 $X=19520 $Y=66450
X380 45 VDDA 41 pmos1v2hvt_4_CDNS_7833375749227 $T=20140 118675 1 0 $X=19520 $Y=93275
X381 45 VDDA 41 pmos1v2hvt_4_CDNS_7833375749227 $T=31380 67170 0 0 $X=30760 $Y=66450
X382 45 VDDA 45 pmos1v2hvt_4_CDNS_7833375749227 $T=31380 118675 1 0 $X=30760 $Y=93275
X383 45 VDDA 45 pmos1v2hvt_4_CDNS_7833375749227 $T=42620 67170 0 0 $X=42000 $Y=66450
X384 45 VDDA 41 pmos1v2hvt_4_CDNS_7833375749227 $T=42620 118675 1 0 $X=42000 $Y=93275
X385 45 VDDA 45 pmos1v2hvt_4_CDNS_7833375749227 $T=63860 67170 1 180 $X=53240 $Y=66450
X386 45 VDDA 41 pmos1v2hvt_4_CDNS_7833375749227 $T=63860 118675 0 180 $X=53240 $Y=93275
X387 45 VDDA 41 pmos1v2hvt_4_CDNS_7833375749227 $T=75100 67170 1 180 $X=64480 $Y=66450
X388 45 VDDA 45 pmos1v2hvt_4_CDNS_7833375749227 $T=75100 118675 0 180 $X=64480 $Y=93275
X389 45 VDDA 45 pmos1v2hvt_4_CDNS_7833375749227 $T=86340 67170 1 180 $X=75720 $Y=66450
X390 45 VDDA 41 pmos1v2hvt_4_CDNS_7833375749227 $T=86340 118675 0 180 $X=75720 $Y=93275
X391 45 VDDA 41 pmos1v2hvt_4_CDNS_7833375749227 $T=97580 67170 1 180 $X=86960 $Y=66450
X392 45 VDDA 45 pmos1v2hvt_4_CDNS_7833375749227 $T=97580 118675 0 180 $X=86960 $Y=93275
X393 GNDA rnpolym_CDNS_7833375749232 $T=328185 10040 0 0 $X=327935 $Y=9300
X394 42 GNDA 44 nmos1v2hvt_4_CDNS_7833375749233 $T=5090 6850 0 0 $X=4470 $Y=6130
X395 42 GNDA 42 nmos1v2hvt_4_CDNS_7833375749233 $T=5090 24100 1 0 $X=4470 $Y=15700
X396 42 GNDA 42 nmos1v2hvt_4_CDNS_7833375749233 $T=10330 6850 0 0 $X=9710 $Y=6130
X397 42 GNDA 44 nmos1v2hvt_4_CDNS_7833375749233 $T=10330 24100 1 0 $X=9710 $Y=15700
X398 19 GNDA 119 nmos1v2hvt_4_CDNS_7833375749233 $T=134790 6850 0 0 $X=134170 $Y=6130
X399 19 GNDA 19 nmos1v2hvt_4_CDNS_7833375749233 $T=134790 24100 1 0 $X=134170 $Y=15700
X400 19 GNDA 19 nmos1v2hvt_4_CDNS_7833375749233 $T=140030 6850 0 0 $X=139410 $Y=6130
X401 19 GNDA 119 nmos1v2hvt_4_CDNS_7833375749233 $T=140030 24100 1 0 $X=139410 $Y=15700
X402 VDDA pmos1v2hvt_4_CDNS_7833375749242 $T=5660 67170 0 0 $X=5040 $Y=66450
X403 VDDA pmos1v2hvt_4_CDNS_7833375749242 $T=5660 118675 1 0 $X=5040 $Y=93275
X404 VDDA pmos1v2hvt_4_CDNS_7833375749242 $T=98820 67170 0 0 $X=98200 $Y=66450
X405 VDDA pmos1v2hvt_4_CDNS_7833375749242 $T=98820 118675 1 0 $X=98200 $Y=93275
X406 3 19 GNDA 3 nmos1v2hvt_4_CDNS_7833375749243 $T=134790 26535 0 0 $X=134170 $Y=25815
X407 4 3 GNDA 4 nmos1v2hvt_4_CDNS_7833375749243 $T=134790 37020 0 0 $X=134170 $Y=36300
X408 3 119 GNDA 46 nmos1v2hvt_4_CDNS_7833375749243 $T=144370 26535 0 0 $X=143750 $Y=25815
X409 GNDA rnpolym_CDNS_7833375749246 $T=169025 10040 0 0 $X=168775 $Y=9300
X410 GNDA rnpolym_CDNS_7833375749246 $T=169025 46440 0 0 $X=168775 $Y=45700
X411 GNDA rnpolym_CDNS_7833375749246 $T=334185 10040 0 0 $X=333935 $Y=9300
X412 GNDA rnpolym_CDNS_7833375749246 $T=334185 46440 0 0 $X=333935 $Y=45700
X413 46 120 CL4X_1 VDDA pmos1v2hvt_4_CDNS_7833375749247 $T=132565 106555 1 0 $X=131945 $Y=96145
X414 46 122 CL4X_2 VDDA pmos1v2hvt_4_CDNS_7833375749247 $T=148765 106555 1 0 $X=148145 $Y=96145
X415 46 124 CJ_G1<0> VDDA pmos1v2hvt_4_CDNS_7833375749250 $T=164625 106555 0 180 $X=162005 $Y=96155
X416 46 126 CJ_G1<5> VDDA pmos1v2hvt_4_CDNS_7833375749252 $T=197365 106555 1 0 $X=196745 $Y=96145
X417 46 128 CJ_G2<5> VDDA pmos1v2hvt_4_CDNS_7833375749252 $T=260010 106555 1 0 $X=259390 $Y=96145
X418 46 130 CJ_G3<5> VDDA pmos1v2hvt_4_CDNS_7833375749252 $T=314365 106555 1 0 $X=313745 $Y=96145
X419 46 132 CJ_G4<5> VDDA pmos1v2hvt_4_CDNS_7833375749252 $T=362605 106555 1 0 $X=361985 $Y=96145
X420 46 134 Ib128nAT VDDA pmos1v2hvt_4_CDNS_7833375749252 $T=378805 106555 1 0 $X=378185 $Y=96145
X421 1 GNDA GNDA 45 44 GNDA GNDA MASCO__A2 $T=122745 36455 0 0 $X=122745 $Y=36455
X422 BG_REF GNDA GNDA 41 44 GNDA GNDA MASCO__A3 $T=122745 14935 0 0 $X=122745 $Y=14935
X423 41 41 VDDA V1000 VDDA V1000 V1000 VDDA MASCO__A4 $T=392045 108275 0 0 $X=392045 $Y=108275
X424 GNDA 1 GNDA 44 45 BG_REF 41 GNDA GNDA MASCO__A5 $T=19065 36455 0 0 $X=19065 $Y=36455
X425 BG_REF 1 GNDA 44 45 BG_REF 41 41 44 MASCO__A5 $T=32025 36455 0 0 $X=32025 $Y=36455
X426 BG_REF 1 GNDA 44 45 BG_REF 41 41 44 MASCO__A5 $T=44985 36455 0 0 $X=44985 $Y=36455
X427 BG_REF 1 GNDA 44 45 BG_REF 41 41 44 MASCO__A5 $T=57945 36455 0 0 $X=57945 $Y=36455
X428 BG_REF BG_REF GNDA 44 41 1 45 41 44 MASCO__A5 $T=70905 36455 0 0 $X=70905 $Y=36455
X429 1 BG_REF GNDA 44 41 1 45 45 44 MASCO__A5 $T=83865 36455 0 0 $X=83865 $Y=36455
X430 1 BG_REF GNDA 44 41 1 45 45 44 MASCO__A5 $T=96825 36455 0 0 $X=96825 $Y=36455
X431 1 BG_REF GNDA 44 41 1 45 45 44 MASCO__A5 $T=109785 36455 0 0 $X=109785 $Y=36455
X432 GNDA BG_REF GNDA 44 41 1 45 GNDA GNDA MASCO__A6 $T=19065 14935 0 0 $X=19065 $Y=14935
X433 1 BG_REF GNDA 44 41 1 45 45 44 MASCO__A6 $T=32025 14935 0 0 $X=32025 $Y=14935
X434 1 BG_REF GNDA 44 41 1 45 45 44 MASCO__A6 $T=44985 14935 0 0 $X=44985 $Y=14935
X435 1 BG_REF GNDA 44 41 1 45 45 44 MASCO__A6 $T=57945 14935 0 0 $X=57945 $Y=14935
X436 1 1 GNDA 44 45 BG_REF 41 45 44 MASCO__A6 $T=70905 14935 0 0 $X=70905 $Y=14935
X437 BG_REF 1 GNDA 44 45 BG_REF 41 41 44 MASCO__A6 $T=83865 14935 0 0 $X=83865 $Y=14935
X438 BG_REF 1 GNDA 44 45 BG_REF 41 41 44 MASCO__A6 $T=96825 14935 0 0 $X=96825 $Y=14935
X439 BG_REF 1 GNDA 44 45 BG_REF 41 41 44 MASCO__A6 $T=109785 14935 0 0 $X=109785 $Y=14935
X440 41 VDDA VDDA V1000 4 47 V1000 V1000 V1000 120
+ VDDA MASCO__A7 $T=106925 108275 0 0 $X=106925 $Y=108275
X441 41 41 VDDA 120 120 V1000 122 122 122 122
+ 120 MASCO__A7 $T=132845 108275 0 0 $X=132845 $Y=108275
X442 41 41 VDDA 124 V1000 51 V1000 53 V1000 55
+ V1000 MASCO__A7 $T=158765 108275 0 0 $X=158765 $Y=108275
X443 41 41 VDDA 57 V1000 126 V1000 126 V1000 126
+ V1000 MASCO__A7 $T=184685 108275 0 0 $X=184685 $Y=108275
X444 41 41 VDDA 126 V1000 59 V1000 61 V1000 63
+ V1000 MASCO__A7 $T=210605 108275 0 0 $X=210605 $Y=108275
X445 41 41 VDDA 65 V1000 67 V1000 128 V1000 128
+ V1000 MASCO__A7 $T=236525 108275 0 0 $X=236525 $Y=108275
X446 41 41 VDDA 128 V1000 128 V1000 69 V1000 71
+ V1000 MASCO__A7 $T=262445 108275 0 0 $X=262445 $Y=108275
X447 41 41 VDDA 73 V1000 75 V1000 77 V1000 130
+ V1000 MASCO__A7 $T=288365 108275 0 0 $X=288365 $Y=108275
X448 41 41 VDDA 130 130 V1000 79 V1000 81 V1000
+ 130 MASCO__A7 $T=314285 108275 0 0 $X=314285 $Y=108275
X449 41 41 VDDA V1000 85 V1000 87 V1000 132 132
+ 83 MASCO__A7 $T=340205 108275 0 0 $X=340205 $Y=108275
X450 41 41 VDDA 132 V1000 134 134 134 134 V1000
+ 132 MASCO__A7 $T=366125 108275 0 0 $X=366125 $Y=108275
C0 41 V1000 8.952e-13 L=3e-05 W=3e-05 m=1 $A=9e-10 $P=0.00012 $[cmims2] $X=366890 $Y=20105 $dt=0
C1 41 V1000 8.952e-13 L=3e-05 W=3e-05 m=1 $A=9e-10 $P=0.00012 $[cmims2] $X=366890 $Y=52105 $dt=0
C2 41 V1000 8.952e-13 L=3e-05 W=3e-05 m=1 $A=9e-10 $P=0.00012 $[cmims2] $X=398890 $Y=20105 $dt=0
C3 41 V1000 8.952e-13 L=3e-05 W=3e-05 m=1 $A=9e-10 $P=0.00012 $[cmims2] $X=398890 $Y=52105 $dt=0
C4 41 V1000 8.952e-13 L=3e-05 W=3e-05 m=1 $A=9e-10 $P=0.00012 $[cmims2] $X=430890 $Y=20105 $dt=0
C5 41 V1000 8.952e-13 L=3e-05 W=3e-05 m=1 $A=9e-10 $P=0.00012 $[cmims2] $X=430890 $Y=52105 $dt=0
.ends REF_V5_fL
