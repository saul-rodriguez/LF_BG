* +++++++++++++++++++++++++++++++++++++++++++++++++++++++++ *
* CDL Netlist:                                              *
*                                                           *
* Cell Name  : BG_STARTUP_fL2                               *
* Netlisted  : Sat Jun 20 14:49:11 2026                     *
* PVS Version: 24.11-s045 Mon Jan 27 22:18:54 PST 2025      *
* +++++++++++++++++++++++++++++++++++++++++++++++++++++++++ *
*.LDD
*.DEVTMPLT 0 MN(nmos1v2hvt) NMOS1V2HVT NDIFF(D) NGATE(G) NDIFF(S) PW1V2(B)
*.DEVTMPLT 1 MP(pmos1v2hvt) PMOS1V2HVT PDIFF(D) PGATE(G) PDIFF(S) NW1V2(B)

* +++++++++++++++++++++++++++++++++++++++++++++++++++++++++ *
* Sub cell: M1_M2_CDNS_781966947810                         *
* +++++++++++++++++++++++++++++++++++++++++++++++++++++++++ *
.subckt M1_M2_CDNS_781966947810 1
** N=1 EP=1 FDC=0
.ends M1_M2_CDNS_781966947810

* +++++++++++++++++++++++++++++++++++++++++++++++++++++++++ *
* Sub cell: M2_M3_CDNS_781966947811                         *
* +++++++++++++++++++++++++++++++++++++++++++++++++++++++++ *
.subckt M2_M3_CDNS_781966947811 1
** N=1 EP=1 FDC=0
.ends M2_M3_CDNS_781966947811

* +++++++++++++++++++++++++++++++++++++++++++++++++++++++++ *
* Sub cell: M2_M3_CDNS_781966947812                         *
* +++++++++++++++++++++++++++++++++++++++++++++++++++++++++ *
.subckt M2_M3_CDNS_781966947812 1
** N=1 EP=1 FDC=0
.ends M2_M3_CDNS_781966947812

* +++++++++++++++++++++++++++++++++++++++++++++++++++++++++ *
* Sub cell: M1_M2_CDNS_781966947816                         *
* +++++++++++++++++++++++++++++++++++++++++++++++++++++++++ *
.subckt M1_M2_CDNS_781966947816 1
** N=1 EP=1 FDC=0
.ends M1_M2_CDNS_781966947816

* +++++++++++++++++++++++++++++++++++++++++++++++++++++++++ *
* Sub cell: PG_M1_CDNS_781966947817                         *
* +++++++++++++++++++++++++++++++++++++++++++++++++++++++++ *
.subckt PG_M1_CDNS_781966947817 1
** N=1 EP=1 FDC=0
.ends PG_M1_CDNS_781966947817

* +++++++++++++++++++++++++++++++++++++++++++++++++++++++++ *
* Sub cell: PG_M1_CDNS_7819669478110                        *
* +++++++++++++++++++++++++++++++++++++++++++++++++++++++++ *
.subckt PG_M1_CDNS_7819669478110 1
** N=1 EP=1 FDC=0
.ends PG_M1_CDNS_7819669478110

* +++++++++++++++++++++++++++++++++++++++++++++++++++++++++ *
* Sub cell: M1_M2_CDNS_7819669478111                        *
* +++++++++++++++++++++++++++++++++++++++++++++++++++++++++ *
.subckt M1_M2_CDNS_7819669478111 1
** N=1 EP=1 FDC=0
.ends M1_M2_CDNS_7819669478111

* +++++++++++++++++++++++++++++++++++++++++++++++++++++++++ *
* Sub cell: Contact_CDNS_781966947811                       *
* +++++++++++++++++++++++++++++++++++++++++++++++++++++++++ *
.subckt Contact_CDNS_781966947811 1
** N=1 EP=1 FDC=0
.ends Contact_CDNS_781966947811

* +++++++++++++++++++++++++++++++++++++++++++++++++++++++++ *
* Sub cell: Contact_CDNS_781966947812                       *
* +++++++++++++++++++++++++++++++++++++++++++++++++++++++++ *
.subckt Contact_CDNS_781966947812 1
** N=1 EP=1 FDC=0
.ends Contact_CDNS_781966947812

* +++++++++++++++++++++++++++++++++++++++++++++++++++++++++ *
* Sub cell: Contact_CDNS_781966947813                       *
* +++++++++++++++++++++++++++++++++++++++++++++++++++++++++ *
.subckt Contact_CDNS_781966947813 1
** N=1 EP=1 FDC=0
.ends Contact_CDNS_781966947813

* +++++++++++++++++++++++++++++++++++++++++++++++++++++++++ *
* Sub cell: pmos1v2hvt_4_CDNS_781966947810                  *
* +++++++++++++++++++++++++++++++++++++++++++++++++++++++++ *
.subckt pmos1v2hvt_4_CDNS_781966947810 1 2 3 4
** N=4 EP=4 FDC=1
X0 2 Contact_CDNS_781966947811 $T=-245 180 0 0 $X=-245 $Y=55
X1 3 Contact_CDNS_781966947811 $T=4095 180 0 0 $X=4095 $Y=55
X2 1 Contact_CDNS_781966947812 $T=70 8140 0 0 $X=0 $Y=8140
X3 2 Contact_CDNS_781966947813 $T=-275 15 0 0 $X=-275 $Y=0
X4 3 Contact_CDNS_781966947813 $T=4065 15 0 0 $X=4065 $Y=0
M0 3 1 2 2 pmos1v2hvt L=4e-06 W=8e-06 AD=2.4e-12 AS=2.4e-12 PD=8.6e-06 PS=8.6e-06 m=1 $X=0 $Y=0 $dt=1
.ends pmos1v2hvt_4_CDNS_781966947810

* +++++++++++++++++++++++++++++++++++++++++++++++++++++++++ *
* Sub cell: Contact_CDNS_781966947816                       *
* +++++++++++++++++++++++++++++++++++++++++++++++++++++++++ *
.subckt Contact_CDNS_781966947816 1
** N=1 EP=1 FDC=0
.ends Contact_CDNS_781966947816

* +++++++++++++++++++++++++++++++++++++++++++++++++++++++++ *
* Sub cell: Contact_CDNS_781966947817                       *
* +++++++++++++++++++++++++++++++++++++++++++++++++++++++++ *
.subckt Contact_CDNS_781966947817 1
** N=1 EP=1 FDC=0
.ends Contact_CDNS_781966947817

* +++++++++++++++++++++++++++++++++++++++++++++++++++++++++ *
* Sub cell: nmos1v2hvt_4_CDNS_781966947815                  *
* +++++++++++++++++++++++++++++++++++++++++++++++++++++++++ *
.subckt nmos1v2hvt_4_CDNS_781966947815 1 2 3
** N=3 EP=3 FDC=1
X0 2 Contact_CDNS_781966947816 $T=-245 130 0 0 $X=-245 $Y=0
X1 3 Contact_CDNS_781966947816 $T=295 130 0 0 $X=295 $Y=0
X2 1 Contact_CDNS_781966947817 $T=-30 1150 0 0 $X=-120 $Y=1150
M0 3 1 2 2 nmos1v2hvt L=2e-07 W=1e-06 AD=3e-13 AS=3e-13 PD=1.6e-06 PS=1.6e-06 m=1 $X=0 $Y=0 $dt=0
.ends nmos1v2hvt_4_CDNS_781966947815

* +++++++++++++++++++++++++++++++++++++++++++++++++++++++++ *
* Sub cell: Contact_CDNS_7819669478110                      *
* +++++++++++++++++++++++++++++++++++++++++++++++++++++++++ *
.subckt Contact_CDNS_7819669478110 1
** N=1 EP=1 FDC=0
.ends Contact_CDNS_7819669478110

* +++++++++++++++++++++++++++++++++++++++++++++++++++++++++ *
* Sub cell: AbutContact_CDNS_7819669478111                  *
* +++++++++++++++++++++++++++++++++++++++++++++++++++++++++ *
.subckt AbutContact_CDNS_7819669478111 1
** N=1 EP=1 FDC=0
.ends AbutContact_CDNS_7819669478111

* +++++++++++++++++++++++++++++++++++++++++++++++++++++++++ *
* Sub cell: pmos1v2hvt_4_CDNS_781966947819                  *
* +++++++++++++++++++++++++++++++++++++++++++++++++++++++++ *
.subckt pmos1v2hvt_4_CDNS_781966947819 1 2 3 4
** N=4 EP=4 FDC=1
X0 2 Contact_CDNS_7819669478110 $T=-245 180 0 0 $X=-245 $Y=55
X1 3 Contact_CDNS_7819669478110 $T=595 180 0 0 $X=595 $Y=55
X2 2 AbutContact_CDNS_7819669478111 $T=-430 -560 0 0 $X=-520 $Y=-620
M0 3 1 2 2 pmos1v2hvt L=5e-07 W=2e-06 AD=6e-13 AS=6e-13 PD=2.6e-06 PS=2.6e-06 m=1 $X=0 $Y=0 $dt=1
.ends pmos1v2hvt_4_CDNS_781966947819

* +++++++++++++++++++++++++++++++++++++++++++++++++++++++++ *
* Sub cell: nmos1v2hvt_4_CDNS_7819669478112                 *
* +++++++++++++++++++++++++++++++++++++++++++++++++++++++++ *
.subckt nmos1v2hvt_4_CDNS_7819669478112 1 2 3
** N=3 EP=3 FDC=1
X0 2 Contact_CDNS_781966947816 $T=-245 130 0 0 $X=-245 $Y=0
X1 1 Contact_CDNS_781966947816 $T=10095 130 0 0 $X=10095 $Y=0
M0 1 1 2 3 nmos1v2hvt L=1e-05 W=1e-06 AD=3e-13 AS=3e-13 PD=1.6e-06 PS=1.6e-06 m=1 $X=0 $Y=0 $dt=0
.ends nmos1v2hvt_4_CDNS_7819669478112

* +++++++++++++++++++++++++++++++++++++++++++++++++++++++++ *
* Sub cell: Contact_CDNS_7819669478116                      *
* +++++++++++++++++++++++++++++++++++++++++++++++++++++++++ *
.subckt Contact_CDNS_7819669478116 1 2
** N=2 EP=2 FDC=0
.ends Contact_CDNS_7819669478116

* +++++++++++++++++++++++++++++++++++++++++++++++++++++++++ *
* Sub cell: Contact_CDNS_7819669478117                      *
* +++++++++++++++++++++++++++++++++++++++++++++++++++++++++ *
.subckt Contact_CDNS_7819669478117 1 2
** N=2 EP=2 FDC=0
.ends Contact_CDNS_7819669478117

* +++++++++++++++++++++++++++++++++++++++++++++++++++++++++ *
* Sub cell: nmos1v2hvt_4_CDNS_7819669478115                 *
* +++++++++++++++++++++++++++++++++++++++++++++++++++++++++ *
.subckt nmos1v2hvt_4_CDNS_7819669478115 1 2 3
** N=3 EP=3 FDC=1
X0 1 Contact_CDNS_781966947812 $T=70 4140 0 0 $X=0 $Y=4140
X1 2 2 Contact_CDNS_7819669478116 $T=-245 130 0 0 $X=-245 $Y=0
X2 3 2 Contact_CDNS_7819669478116 $T=4095 130 0 0 $X=4095 $Y=0
X3 2 2 Contact_CDNS_7819669478117 $T=-275 115 0 0 $X=-275 $Y=0
X4 3 2 Contact_CDNS_7819669478117 $T=4065 115 0 0 $X=4065 $Y=0
M0 3 1 2 2 nmos1v2hvt L=4e-06 W=4e-06 AD=1.2e-12 AS=1.2e-12 PD=4.6e-06 PS=4.6e-06 m=1 $X=0 $Y=0 $dt=0
.ends nmos1v2hvt_4_CDNS_7819669478115

* +++++++++++++++++++++++++++++++++++++++++++++++++++++++++ *
* Sub cell: Contact_CDNS_7819669478120                      *
* +++++++++++++++++++++++++++++++++++++++++++++++++++++++++ *
.subckt Contact_CDNS_7819669478120 1
** N=1 EP=1 FDC=0
.ends Contact_CDNS_7819669478120

* +++++++++++++++++++++++++++++++++++++++++++++++++++++++++ *
* Sub cell: pmos1v2hvt_4_CDNS_7819669478119                 *
* +++++++++++++++++++++++++++++++++++++++++++++++++++++++++ *
.subckt pmos1v2hvt_4_CDNS_7819669478119 1 2 3 4
** N=4 EP=4 FDC=1
X0 2 Contact_CDNS_7819669478110 $T=-245 180 0 0 $X=-245 $Y=55
X1 3 Contact_CDNS_7819669478110 $T=595 180 0 0 $X=595 $Y=55
X2 2 AbutContact_CDNS_7819669478111 $T=-430 -560 0 0 $X=-520 $Y=-620
X3 1 Contact_CDNS_7819669478120 $T=120 2120 0 0 $X=0 $Y=2120
M0 3 1 2 2 pmos1v2hvt L=5e-07 W=2e-06 AD=6e-13 AS=6e-13 PD=2.6e-06 PS=2.6e-06 m=1 $X=0 $Y=0 $dt=1
.ends pmos1v2hvt_4_CDNS_7819669478119

* +++++++++++++++++++++++++++++++++++++++++++++++++++++++++ *
* Sub cell: pmos1v2hvt_4_CDNS_7819669478121                 *
* +++++++++++++++++++++++++++++++++++++++++++++++++++++++++ *
.subckt pmos1v2hvt_4_CDNS_7819669478121 1 2 3 4
** N=4 EP=4 FDC=1
X0 1 Contact_CDNS_781966947817 $T=-30 2150 0 0 $X=-120 $Y=2150
X1 2 Contact_CDNS_7819669478110 $T=-245 180 0 0 $X=-245 $Y=55
X2 3 Contact_CDNS_7819669478110 $T=295 180 0 0 $X=295 $Y=55
M0 3 1 2 2 pmos1v2hvt L=2e-07 W=2e-06 AD=6e-13 AS=6e-13 PD=2.6e-06 PS=2.6e-06 m=1 $X=0 $Y=0 $dt=1
.ends pmos1v2hvt_4_CDNS_7819669478121

* +++++++++++++++++++++++++++++++++++++++++++++++++++++++++ *
* Sub cell: nmos1v2hvt_4_CDNS_7819669478123                 *
* +++++++++++++++++++++++++++++++++++++++++++++++++++++++++ *
.subckt nmos1v2hvt_4_CDNS_7819669478123 1 2 3
** N=3 EP=3 FDC=1
X0 2 Contact_CDNS_781966947816 $T=-245 130 0 0 $X=-245 $Y=0
X1 3 Contact_CDNS_781966947816 $T=595 130 0 0 $X=595 $Y=0
M0 3 1 2 2 nmos1v2hvt L=5e-07 W=1e-06 AD=3e-13 AS=3e-13 PD=1.6e-06 PS=1.6e-06 m=1 $X=0 $Y=0 $dt=0
.ends nmos1v2hvt_4_CDNS_7819669478123

* +++++++++++++++++++++++++++++++++++++++++++++++++++++++++ *
* Sub cell: AbutContact_CDNS_7819669478127                  *
* +++++++++++++++++++++++++++++++++++++++++++++++++++++++++ *
.subckt AbutContact_CDNS_7819669478127 1 2
** N=2 EP=2 FDC=0
.ends AbutContact_CDNS_7819669478127

* +++++++++++++++++++++++++++++++++++++++++++++++++++++++++ *
* Sub cell: pmos1v2hvt_4_CDNS_7819669478125                 *
* +++++++++++++++++++++++++++++++++++++++++++++++++++++++++ *
.subckt pmos1v2hvt_4_CDNS_7819669478125 1 2 3 4 5
** N=5 EP=5 FDC=1
X0 2 Contact_CDNS_781966947811 $T=-245 180 0 0 $X=-245 $Y=55
X1 3 Contact_CDNS_781966947811 $T=2095 180 0 0 $X=2095 $Y=55
X2 2 Contact_CDNS_781966947813 $T=-275 15 0 0 $X=-275 $Y=0
X3 3 Contact_CDNS_781966947813 $T=2065 15 0 0 $X=2065 $Y=0
X4 4 5 AbutContact_CDNS_7819669478127 $T=-430 -560 0 0 $X=-520 $Y=-620
M0 3 1 2 4 pmos1v2hvt L=2e-06 W=8e-06 AD=2.4e-12 AS=2.4e-12 PD=8.6e-06 PS=8.6e-06 m=1 $X=0 $Y=0 $dt=1
.ends pmos1v2hvt_4_CDNS_7819669478125

* +++++++++++++++++++++++++++++++++++++++++++++++++++++++++ *
* Sub cell: pmos1v2hvt_4_CDNS_7819669478128                 *
* +++++++++++++++++++++++++++++++++++++++++++++++++++++++++ *
.subckt pmos1v2hvt_4_CDNS_7819669478128 1 2
** N=2 EP=2 FDC=1
X0 1 Contact_CDNS_781966947811 $T=-245 180 0 0 $X=-245 $Y=55
X1 1 Contact_CDNS_781966947811 $T=595 180 0 0 $X=595 $Y=55
X2 1 Contact_CDNS_781966947813 $T=-275 15 0 0 $X=-275 $Y=0
X3 1 Contact_CDNS_781966947813 $T=565 15 0 0 $X=565 $Y=0
X4 1 AbutContact_CDNS_7819669478111 $T=-430 -560 0 0 $X=-520 $Y=-620
X5 1 Contact_CDNS_7819669478120 $T=120 8140 0 0 $X=0 $Y=8140
M0 1 1 1 1 pmos1v2hvt L=5e-07 W=8e-06 AD=2.4e-12 AS=2.4e-12 PD=8.6e-06 PS=8.6e-06 m=1 $X=0 $Y=0 $dt=1
.ends pmos1v2hvt_4_CDNS_7819669478128

* +++++++++++++++++++++++++++++++++++++++++++++++++++++++++ *
* Sub cell: pmos1v2hvt_4_CDNS_7819669478129                 *
* +++++++++++++++++++++++++++++++++++++++++++++++++++++++++ *
.subckt pmos1v2hvt_4_CDNS_7819669478129 1 2
** N=2 EP=2 FDC=1
X0 1 Contact_CDNS_781966947811 $T=-245 180 0 0 $X=-245 $Y=55
X1 1 Contact_CDNS_781966947811 $T=1095 180 0 0 $X=1095 $Y=55
M0 1 1 1 1 pmos1v2hvt L=1e-06 W=8e-06 AD=2.4e-12 AS=2.4e-12 PD=8.6e-06 PS=8.6e-06 m=1 $X=0 $Y=0 $dt=1
.ends pmos1v2hvt_4_CDNS_7819669478129

* +++++++++++++++++++++++++++++++++++++++++++++++++++++++++ *
* Sub cell: Contact_CDNS_7819669478134                      *
* +++++++++++++++++++++++++++++++++++++++++++++++++++++++++ *
.subckt Contact_CDNS_7819669478134 1 2
** N=2 EP=2 FDC=0
.ends Contact_CDNS_7819669478134

* +++++++++++++++++++++++++++++++++++++++++++++++++++++++++ *
* Sub cell: nmos1v2hvt_4_CDNS_7819669478132                 *
* +++++++++++++++++++++++++++++++++++++++++++++++++++++++++ *
.subckt nmos1v2hvt_4_CDNS_7819669478132 1 2 3
** N=3 EP=3 FDC=2
X0 2 Contact_CDNS_7819669478110 $T=-245 180 0 0 $X=-245 $Y=55
X1 3 Contact_CDNS_7819669478110 $T=295 180 0 0 $X=295 $Y=55
X2 2 Contact_CDNS_7819669478110 $T=835 180 0 0 $X=835 $Y=55
X3 2 2 Contact_CDNS_7819669478134 $T=-275 165 0 0 $X=-275 $Y=0
X4 3 2 Contact_CDNS_7819669478134 $T=265 165 0 0 $X=265 $Y=0
X5 2 2 Contact_CDNS_7819669478134 $T=805 165 0 0 $X=805 $Y=0
M0 3 1 2 2 nmos1v2hvt L=2e-07 W=2e-06 AD=6.8e-13 AS=6e-13 PD=2.68e-06 PS=2.6e-06 m=1 $X=0 $Y=0 $dt=0
M1 2 1 3 2 nmos1v2hvt L=2e-07 W=2e-06 AD=6e-13 AS=6.8e-13 PD=2.6e-06 PS=2.68e-06 m=1 $X=540 $Y=0 $dt=0
.ends nmos1v2hvt_4_CDNS_7819669478132

* +++++++++++++++++++++++++++++++++++++++++++++++++++++++++ *
* Sub cell: BG_STARTUP_fL2                                  *
* +++++++++++++++++++++++++++++++++++++++++++++++++++++++++ *
.subckt BG_STARTUP_fL2 6 14 11 10 12 5 13 2
** N=14 EP=8 FDC=45
X0 1 M1_M2_CDNS_781966947810 $T=12670 25995 0 0 $X=12390 $Y=25860
X1 2 M1_M2_CDNS_781966947810 $T=12670 26465 0 0 $X=12390 $Y=26330
X2 2 M1_M2_CDNS_781966947810 $T=15190 26465 0 0 $X=14910 $Y=26330
X3 1 M1_M2_CDNS_781966947810 $T=16630 25995 0 0 $X=16350 $Y=25860
X4 1 M1_M2_CDNS_781966947810 $T=19150 25995 0 0 $X=18870 $Y=25860
X5 2 M1_M2_CDNS_781966947810 $T=19150 26465 0 0 $X=18870 $Y=26330
X6 2 M1_M2_CDNS_781966947810 $T=21670 26465 0 0 $X=21390 $Y=26330
X7 1 M1_M2_CDNS_781966947810 $T=23110 25995 0 0 $X=22830 $Y=25860
X8 1 M1_M2_CDNS_781966947810 $T=25630 25995 0 0 $X=25350 $Y=25860
X9 2 M1_M2_CDNS_781966947810 $T=25630 26465 0 0 $X=25350 $Y=26330
X10 1 M1_M2_CDNS_781966947810 $T=28870 25995 0 0 $X=28590 $Y=25860
X11 2 M1_M2_CDNS_781966947810 $T=28870 26465 0 0 $X=28590 $Y=26330
X12 2 M1_M2_CDNS_781966947810 $T=31390 26465 0 0 $X=31110 $Y=26330
X13 1 M1_M2_CDNS_781966947810 $T=32830 25995 0 0 $X=32550 $Y=25860
X14 1 M1_M2_CDNS_781966947810 $T=35350 25995 0 0 $X=35070 $Y=25860
X15 2 M1_M2_CDNS_781966947810 $T=35350 26465 0 0 $X=35070 $Y=26330
X16 2 M1_M2_CDNS_781966947810 $T=37870 26465 0 0 $X=37590 $Y=26330
X17 1 M1_M2_CDNS_781966947810 $T=39310 25995 0 0 $X=39030 $Y=25860
X18 1 M1_M2_CDNS_781966947810 $T=41830 25995 0 0 $X=41550 $Y=25860
X19 2 M1_M2_CDNS_781966947810 $T=41830 26465 0 0 $X=41550 $Y=26330
X20 3 M2_M3_CDNS_781966947811 $T=11730 16125 1 0 $X=11400 $Y=15580
X21 3 M2_M3_CDNS_781966947811 $T=11730 36335 0 0 $X=11400 $Y=35790
X22 4 M2_M3_CDNS_781966947811 $T=13610 14835 1 0 $X=13280 $Y=14290
X23 5 M2_M3_CDNS_781966947811 $T=13610 37625 0 0 $X=13280 $Y=37080
X24 3 M2_M3_CDNS_781966947811 $T=14995 41815 0 90 $X=14450 $Y=41485
X25 3 M2_M3_CDNS_781966947811 $T=14970 16125 1 0 $X=14640 $Y=15580
X26 3 M2_M3_CDNS_781966947811 $T=14970 36335 0 0 $X=14640 $Y=35790
X27 5 M2_M3_CDNS_781966947811 $T=16850 13545 1 0 $X=16520 $Y=13000
X28 4 M2_M3_CDNS_781966947811 $T=16850 38915 0 0 $X=16520 $Y=38370
X29 3 M2_M3_CDNS_781966947811 $T=18210 16125 1 0 $X=17880 $Y=15580
X30 3 M2_M3_CDNS_781966947811 $T=18210 36335 0 0 $X=17880 $Y=35790
X31 6 M2_M3_CDNS_781966947811 $T=20235 43015 0 90 $X=19690 $Y=42685
X32 4 M2_M3_CDNS_781966947811 $T=20550 14835 1 0 $X=20220 $Y=14290
X33 5 M2_M3_CDNS_781966947811 $T=20550 37625 0 0 $X=20220 $Y=37080
X34 3 M2_M3_CDNS_781966947811 $T=21450 16125 1 0 $X=21120 $Y=15580
X35 3 M2_M3_CDNS_781966947811 $T=21450 36335 0 0 $X=21120 $Y=35790
X36 5 M2_M3_CDNS_781966947811 $T=23330 13545 1 0 $X=23000 $Y=13000
X37 4 M2_M3_CDNS_781966947811 $T=23330 38915 0 0 $X=23000 $Y=38370
X38 3 M2_M3_CDNS_781966947811 $T=24690 16125 1 0 $X=24360 $Y=15580
X39 3 M2_M3_CDNS_781966947811 $T=24690 36335 0 0 $X=24360 $Y=35790
X40 4 M2_M3_CDNS_781966947811 $T=27030 14835 1 0 $X=26700 $Y=14290
X41 5 M2_M3_CDNS_781966947811 $T=27030 37625 0 0 $X=26700 $Y=37080
X42 3 M2_M3_CDNS_781966947811 $T=27930 16125 1 0 $X=27600 $Y=15580
X43 3 M2_M3_CDNS_781966947811 $T=27930 36335 0 0 $X=27600 $Y=35790
X44 6 M2_M3_CDNS_781966947811 $T=29825 43015 0 90 $X=29280 $Y=42685
X45 4 M2_M3_CDNS_781966947811 $T=30270 14835 1 0 $X=29940 $Y=14290
X46 5 M2_M3_CDNS_781966947811 $T=30270 37625 0 0 $X=29940 $Y=37080
X47 3 M2_M3_CDNS_781966947811 $T=31170 16125 1 0 $X=30840 $Y=15580
X48 3 M2_M3_CDNS_781966947811 $T=31170 36335 0 0 $X=30840 $Y=35790
X49 5 M2_M3_CDNS_781966947811 $T=33050 13545 1 0 $X=32720 $Y=13000
X50 4 M2_M3_CDNS_781966947811 $T=33050 38915 0 0 $X=32720 $Y=38370
X51 3 M2_M3_CDNS_781966947811 $T=34410 16125 1 0 $X=34080 $Y=15580
X52 3 M2_M3_CDNS_781966947811 $T=34410 36335 0 0 $X=34080 $Y=35790
X53 3 M2_M3_CDNS_781966947811 $T=35065 41815 0 90 $X=34520 $Y=41485
X54 4 M2_M3_CDNS_781966947811 $T=36750 14835 1 0 $X=36420 $Y=14290
X55 5 M2_M3_CDNS_781966947811 $T=36750 37625 0 0 $X=36420 $Y=37080
X56 3 M2_M3_CDNS_781966947811 $T=37650 16125 1 0 $X=37320 $Y=15580
X57 3 M2_M3_CDNS_781966947811 $T=37650 36335 0 0 $X=37320 $Y=35790
X58 5 M2_M3_CDNS_781966947811 $T=39530 13550 1 0 $X=39200 $Y=13005
X59 4 M2_M3_CDNS_781966947811 $T=39530 38910 0 0 $X=39200 $Y=38365
X60 3 M2_M3_CDNS_781966947811 $T=40890 16125 1 0 $X=40560 $Y=15580
X61 3 M2_M3_CDNS_781966947811 $T=40890 36335 0 0 $X=40560 $Y=35790
X62 4 M2_M3_CDNS_781966947811 $T=43230 14835 1 0 $X=42900 $Y=14290
X63 5 M2_M3_CDNS_781966947811 $T=43230 37625 0 0 $X=42900 $Y=37080
X64 4 M2_M3_CDNS_781966947812 $T=6210 14835 0 0 $X=5710 $Y=14290
X65 4 M2_M3_CDNS_781966947812 $T=6210 38915 0 0 $X=5710 $Y=38370
X66 5 M2_M3_CDNS_781966947812 $T=7410 13545 0 0 $X=6910 $Y=13000
X67 5 M2_M3_CDNS_781966947812 $T=7410 37625 0 0 $X=6910 $Y=37080
X68 3 M2_M3_CDNS_781966947812 $T=8610 16125 0 0 $X=8110 $Y=15580
X69 3 M2_M3_CDNS_781966947812 $T=8610 36335 0 0 $X=8110 $Y=35790
X70 3 M2_M3_CDNS_781966947812 $T=45890 16125 0 0 $X=45390 $Y=15580
X71 3 M2_M3_CDNS_781966947812 $T=45890 36335 0 0 $X=45390 $Y=35790
X72 4 M2_M3_CDNS_781966947812 $T=47090 14835 0 0 $X=46590 $Y=14290
X73 4 M2_M3_CDNS_781966947812 $T=47090 38915 0 0 $X=46590 $Y=38370
X74 5 M2_M3_CDNS_781966947812 $T=48290 13545 0 0 $X=47790 $Y=13000
X75 5 M2_M3_CDNS_781966947812 $T=48290 37625 0 0 $X=47790 $Y=37080
X76 7 M1_M2_CDNS_781966947816 $T=46470 9965 0 0 $X=46015 $Y=9480
X77 5 M1_M2_CDNS_781966947816 $T=48275 12415 0 0 $X=47820 $Y=11930
X78 8 PG_M1_CDNS_781966947817 $T=52230 9095 0 0 $X=52100 $Y=8815
X79 8 PG_M1_CDNS_781966947817 $T=52475 7560 0 0 $X=52345 $Y=7280
X80 9 PG_M1_CDNS_781966947817 $T=53910 7580 0 0 $X=53780 $Y=7300
X81 10 PG_M1_CDNS_7819669478110 $T=9770 49360 0 0 $X=9490 $Y=49080
X82 11 PG_M1_CDNS_7819669478110 $T=16780 7265 0 0 $X=16500 $Y=6985
X83 11 PG_M1_CDNS_7819669478110 $T=18520 7265 0 0 $X=18240 $Y=6985
X84 10 M1_M2_CDNS_7819669478111 $T=9770 49330 0 0 $X=9490 $Y=49020
X85 11 M1_M2_CDNS_7819669478111 $T=16780 7260 0 0 $X=16500 $Y=6950
X86 11 M1_M2_CDNS_7819669478111 $T=18520 7265 0 0 $X=18240 $Y=6955
X87 12 M1_M2_CDNS_7819669478111 $T=54255 6345 0 0 $X=53975 $Y=6035
X88 6 13 3 14 pmos1v2hvt_4_CDNS_781966947810 $T=18720 51820 0 180 $X=14100 $Y=43420
X89 6 13 6 14 pmos1v2hvt_4_CDNS_781966947810 $T=23960 51820 0 180 $X=19340 $Y=43420
X90 6 13 7 14 pmos1v2hvt_4_CDNS_781966947810 $T=29200 51820 0 180 $X=24580 $Y=43420
X91 6 13 6 14 pmos1v2hvt_4_CDNS_781966947810 $T=34440 51820 0 180 $X=29820 $Y=43420
X92 6 13 3 14 pmos1v2hvt_4_CDNS_781966947810 $T=39680 51820 0 180 $X=35060 $Y=43420
X93 8 14 9 nmos1v2hvt_4_CDNS_781966947815 $T=52370 5805 0 0 $X=51750 $Y=5085
X94 9 14 12 nmos1v2hvt_4_CDNS_781966947815 $T=53810 5805 0 0 $X=53190 $Y=5085
X95 10 13 6 14 pmos1v2hvt_4_CDNS_781966947819 $T=9520 51820 1 0 $X=8900 $Y=49420
X96 1 14 14 nmos1v2hvt_4_CDNS_7819669478112 $T=35920 6615 0 0 $X=35300 $Y=5895
X97 7 1 14 nmos1v2hvt_4_CDNS_7819669478112 $T=35920 9450 0 0 $X=35300 $Y=8730
X98 4 14 5 nmos1v2hvt_4_CDNS_7819669478115 $T=21640 6615 0 0 $X=21020 $Y=5895
X99 4 14 4 nmos1v2hvt_4_CDNS_7819669478115 $T=26880 6615 0 0 $X=26260 $Y=5895
X100 5 13 8 14 pmos1v2hvt_4_CDNS_7819669478119 $T=50390 11870 1 0 $X=49770 $Y=9470
X101 8 13 9 14 pmos1v2hvt_4_CDNS_7819669478121 $T=52130 11875 1 0 $X=51510 $Y=9465
X102 9 13 12 14 pmos1v2hvt_4_CDNS_7819669478121 $T=53570 11875 1 0 $X=52950 $Y=9465
X103 11 14 5 nmos1v2hvt_4_CDNS_7819669478123 $T=16530 5805 0 0 $X=15910 $Y=5085
X104 11 14 4 nmos1v2hvt_4_CDNS_7819669478123 $T=18270 5805 0 0 $X=17650 $Y=5085
X105 1 3 4 13 14 pmos1v2hvt_4_CDNS_7819669478125 $T=11670 17330 0 0 $X=11050 $Y=16610
X106 2 3 5 13 14 pmos1v2hvt_4_CDNS_7819669478125 $T=11670 35130 1 0 $X=11050 $Y=26730
X107 2 3 5 13 14 pmos1v2hvt_4_CDNS_7819669478125 $T=14910 17330 0 0 $X=14290 $Y=16610
X108 1 3 4 13 14 pmos1v2hvt_4_CDNS_7819669478125 $T=14910 35130 1 0 $X=14290 $Y=26730
X109 1 3 4 13 14 pmos1v2hvt_4_CDNS_7819669478125 $T=18150 17330 0 0 $X=17530 $Y=16610
X110 2 3 5 13 14 pmos1v2hvt_4_CDNS_7819669478125 $T=18150 35130 1 0 $X=17530 $Y=26730
X111 2 3 5 13 14 pmos1v2hvt_4_CDNS_7819669478125 $T=21390 17330 0 0 $X=20770 $Y=16610
X112 1 3 4 13 14 pmos1v2hvt_4_CDNS_7819669478125 $T=21390 35130 1 0 $X=20770 $Y=26730
X113 1 3 4 13 14 pmos1v2hvt_4_CDNS_7819669478125 $T=24630 17330 0 0 $X=24010 $Y=16610
X114 2 3 5 13 14 pmos1v2hvt_4_CDNS_7819669478125 $T=24630 35130 1 0 $X=24010 $Y=26730
X115 1 3 4 13 14 pmos1v2hvt_4_CDNS_7819669478125 $T=27870 17330 0 0 $X=27250 $Y=16610
X116 2 3 5 13 14 pmos1v2hvt_4_CDNS_7819669478125 $T=27870 35130 1 0 $X=27250 $Y=26730
X117 2 3 5 13 14 pmos1v2hvt_4_CDNS_7819669478125 $T=31110 17330 0 0 $X=30490 $Y=16610
X118 1 3 4 13 14 pmos1v2hvt_4_CDNS_7819669478125 $T=31110 35130 1 0 $X=30490 $Y=26730
X119 1 3 4 13 14 pmos1v2hvt_4_CDNS_7819669478125 $T=34350 17330 0 0 $X=33730 $Y=16610
X120 2 3 5 13 14 pmos1v2hvt_4_CDNS_7819669478125 $T=34350 35130 1 0 $X=33730 $Y=26730
X121 2 3 5 13 14 pmos1v2hvt_4_CDNS_7819669478125 $T=37590 17330 0 0 $X=36970 $Y=16610
X122 1 3 4 13 14 pmos1v2hvt_4_CDNS_7819669478125 $T=37590 35130 1 0 $X=36970 $Y=26730
X123 1 3 4 13 14 pmos1v2hvt_4_CDNS_7819669478125 $T=40830 17330 0 0 $X=40210 $Y=16610
X124 2 3 5 13 14 pmos1v2hvt_4_CDNS_7819669478125 $T=40830 35130 1 0 $X=40210 $Y=26730
X125 13 14 pmos1v2hvt_4_CDNS_7819669478128 $T=9930 17330 0 0 $X=9310 $Y=16610
X126 13 14 pmos1v2hvt_4_CDNS_7819669478128 $T=9930 35130 1 0 $X=9310 $Y=26730
X127 13 14 pmos1v2hvt_4_CDNS_7819669478128 $T=44070 17330 0 0 $X=43450 $Y=16610
X128 13 14 pmos1v2hvt_4_CDNS_7819669478128 $T=44070 35130 1 0 $X=43450 $Y=26730
X129 13 14 pmos1v2hvt_4_CDNS_7819669478129 $T=12480 51820 1 0 $X=11860 $Y=43420
X130 13 14 pmos1v2hvt_4_CDNS_7819669478129 $T=40920 51820 1 0 $X=40300 $Y=43420
X131 5 14 8 nmos1v2hvt_4_CDNS_7819669478132 $T=50390 5805 0 0 $X=49770 $Y=5085
.ends BG_STARTUP_fL2
