* +++++++++++++++++++++++++++++++++++++++++++++++++++++++++ *
* CDL Netlist:                                              *
*                                                           *
* Cell Name  : BG_STARTUP_fL2                               *
* Netlisted  : Sat Jun 20 14:49:11 2026                     *
* PVS Version: 24.11-s045 Mon Jan 27 22:18:54 PST 2025      *
* +++++++++++++++++++++++++++++++++++++++++++++++++++++++++ *
*.LDD
*.DEVTMPLT 0 MN(nmos1v2hvt) NMOS1V2HVT NDIFF(D) NGATE(G) NDIFF(S) PW1V2(B)
*.DEVTMPLT 1 MP(pmos1v2hvt) PMOS1V2HVT PDIFF(D) PGATE(G) PDIFF(S) NW1V2(B)

* +++++++++++++++++++++++++++++++++++++++++++++++++++++++++ *
* Sub cell: pmos1v2hvt_4_CDNS_781966947810                  *
* +++++++++++++++++++++++++++++++++++++++++++++++++++++++++ *
.subckt pmos1v2hvt_4_CDNS_781966947810 1 2 3
** N=4 EP=3 FDC=1
M0 3 1 2 2 pmos1v2hvt L=4e-06 W=8e-06 AD=2.4e-12 AS=2.4e-12 PD=8.6e-06 PS=8.6e-06 m=1 $X=0 $Y=0 $dt=1
.ends pmos1v2hvt_4_CDNS_781966947810

* +++++++++++++++++++++++++++++++++++++++++++++++++++++++++ *
* Sub cell: nmos1v2hvt_4_CDNS_781966947815                  *
* +++++++++++++++++++++++++++++++++++++++++++++++++++++++++ *
.subckt nmos1v2hvt_4_CDNS_781966947815 1 2 3
** N=3 EP=3 FDC=1
M0 3 1 2 2 nmos1v2hvt L=2e-07 W=1e-06 AD=3e-13 AS=3e-13 PD=1.6e-06 PS=1.6e-06 m=1 $X=0 $Y=0 $dt=0
.ends nmos1v2hvt_4_CDNS_781966947815

* +++++++++++++++++++++++++++++++++++++++++++++++++++++++++ *
* Sub cell: pmos1v2hvt_4_CDNS_781966947819                  *
* +++++++++++++++++++++++++++++++++++++++++++++++++++++++++ *
.subckt pmos1v2hvt_4_CDNS_781966947819 1 2 3
** N=4 EP=3 FDC=1
M0 3 1 2 2 pmos1v2hvt L=5e-07 W=2e-06 AD=6e-13 AS=6e-13 PD=2.6e-06 PS=2.6e-06 m=1 $X=0 $Y=0 $dt=1
.ends pmos1v2hvt_4_CDNS_781966947819

* +++++++++++++++++++++++++++++++++++++++++++++++++++++++++ *
* Sub cell: nmos1v2hvt_4_CDNS_7819669478112                 *
* +++++++++++++++++++++++++++++++++++++++++++++++++++++++++ *
.subckt nmos1v2hvt_4_CDNS_7819669478112 1 2 3
** N=3 EP=3 FDC=1
M0 1 1 2 3 nmos1v2hvt L=1e-05 W=1e-06 AD=3e-13 AS=3e-13 PD=1.6e-06 PS=1.6e-06 m=1 $X=0 $Y=0 $dt=0
.ends nmos1v2hvt_4_CDNS_7819669478112

* +++++++++++++++++++++++++++++++++++++++++++++++++++++++++ *
* Sub cell: nmos1v2hvt_4_CDNS_7819669478115                 *
* +++++++++++++++++++++++++++++++++++++++++++++++++++++++++ *
.subckt nmos1v2hvt_4_CDNS_7819669478115 1 2 3
** N=3 EP=3 FDC=1
M0 3 1 2 2 nmos1v2hvt L=4e-06 W=4e-06 AD=1.2e-12 AS=1.2e-12 PD=4.6e-06 PS=4.6e-06 m=1 $X=0 $Y=0 $dt=0
.ends nmos1v2hvt_4_CDNS_7819669478115

* +++++++++++++++++++++++++++++++++++++++++++++++++++++++++ *
* Sub cell: pmos1v2hvt_4_CDNS_7819669478119                 *
* +++++++++++++++++++++++++++++++++++++++++++++++++++++++++ *
.subckt pmos1v2hvt_4_CDNS_7819669478119 1 2 3
** N=4 EP=3 FDC=1
M0 3 1 2 2 pmos1v2hvt L=5e-07 W=2e-06 AD=6e-13 AS=6e-13 PD=2.6e-06 PS=2.6e-06 m=1 $X=0 $Y=0 $dt=1
.ends pmos1v2hvt_4_CDNS_7819669478119

* +++++++++++++++++++++++++++++++++++++++++++++++++++++++++ *
* Sub cell: pmos1v2hvt_4_CDNS_7819669478121                 *
* +++++++++++++++++++++++++++++++++++++++++++++++++++++++++ *
.subckt pmos1v2hvt_4_CDNS_7819669478121 1 2 3
** N=4 EP=3 FDC=1
M0 3 1 2 2 pmos1v2hvt L=2e-07 W=2e-06 AD=6e-13 AS=6e-13 PD=2.6e-06 PS=2.6e-06 m=1 $X=0 $Y=0 $dt=1
.ends pmos1v2hvt_4_CDNS_7819669478121

* +++++++++++++++++++++++++++++++++++++++++++++++++++++++++ *
* Sub cell: nmos1v2hvt_4_CDNS_7819669478123                 *
* +++++++++++++++++++++++++++++++++++++++++++++++++++++++++ *
.subckt nmos1v2hvt_4_CDNS_7819669478123 1 2 3
** N=3 EP=3 FDC=1
M0 3 1 2 2 nmos1v2hvt L=5e-07 W=1e-06 AD=3e-13 AS=3e-13 PD=1.6e-06 PS=1.6e-06 m=1 $X=0 $Y=0 $dt=0
.ends nmos1v2hvt_4_CDNS_7819669478123

* +++++++++++++++++++++++++++++++++++++++++++++++++++++++++ *
* Sub cell: pmos1v2hvt_4_CDNS_7819669478125                 *
* +++++++++++++++++++++++++++++++++++++++++++++++++++++++++ *
.subckt pmos1v2hvt_4_CDNS_7819669478125 1 2 3 4
** N=5 EP=4 FDC=1
M0 3 1 2 4 pmos1v2hvt L=2e-06 W=8e-06 AD=2.4e-12 AS=2.4e-12 PD=8.6e-06 PS=8.6e-06 m=1 $X=0 $Y=0 $dt=1
.ends pmos1v2hvt_4_CDNS_7819669478125

* +++++++++++++++++++++++++++++++++++++++++++++++++++++++++ *
* Sub cell: pmos1v2hvt_4_CDNS_7819669478128                 *
* +++++++++++++++++++++++++++++++++++++++++++++++++++++++++ *
.subckt pmos1v2hvt_4_CDNS_7819669478128 1
** N=2 EP=1 FDC=1
M0 1 1 1 1 pmos1v2hvt L=5e-07 W=8e-06 AD=2.4e-12 AS=2.4e-12 PD=8.6e-06 PS=8.6e-06 m=1 $X=0 $Y=0 $dt=1
.ends pmos1v2hvt_4_CDNS_7819669478128

* +++++++++++++++++++++++++++++++++++++++++++++++++++++++++ *
* Sub cell: pmos1v2hvt_4_CDNS_7819669478129                 *
* +++++++++++++++++++++++++++++++++++++++++++++++++++++++++ *
.subckt pmos1v2hvt_4_CDNS_7819669478129 1
** N=2 EP=1 FDC=1
M0 1 1 1 1 pmos1v2hvt L=1e-06 W=8e-06 AD=2.4e-12 AS=2.4e-12 PD=8.6e-06 PS=8.6e-06 m=1 $X=0 $Y=0 $dt=1
.ends pmos1v2hvt_4_CDNS_7819669478129

* +++++++++++++++++++++++++++++++++++++++++++++++++++++++++ *
* Sub cell: nmos1v2hvt_4_CDNS_7819669478132                 *
* +++++++++++++++++++++++++++++++++++++++++++++++++++++++++ *
.subckt nmos1v2hvt_4_CDNS_7819669478132 1 2 3
** N=3 EP=3 FDC=2
M0 3 1 2 2 nmos1v2hvt L=2e-07 W=2e-06 AD=6.8e-13 AS=6e-13 PD=2.68e-06 PS=2.6e-06 m=1 $X=0 $Y=0 $dt=0
M1 2 1 3 2 nmos1v2hvt L=2e-07 W=2e-06 AD=6e-13 AS=6.8e-13 PD=2.6e-06 PS=2.68e-06 m=1 $X=540 $Y=0 $dt=0
.ends nmos1v2hvt_4_CDNS_7819669478132

* +++++++++++++++++++++++++++++++++++++++++++++++++++++++++ *
* Sub cell: BG_STARTUP_fL2                                  *
* +++++++++++++++++++++++++++++++++++++++++++++++++++++++++ *
.subckt BG_STARTUP_fL2 BIAS GNDA PD PDN PRN PRN_TRIGGER VDDA VREF
** N=14 EP=8 FDC=45
X88 BIAS VDDA 3 pmos1v2hvt_4_CDNS_781966947810 $T=18720 51820 0 180 $X=14100 $Y=43420
X89 BIAS VDDA BIAS pmos1v2hvt_4_CDNS_781966947810 $T=23960 51820 0 180 $X=19340 $Y=43420
X90 BIAS VDDA 7 pmos1v2hvt_4_CDNS_781966947810 $T=29200 51820 0 180 $X=24580 $Y=43420
X91 BIAS VDDA BIAS pmos1v2hvt_4_CDNS_781966947810 $T=34440 51820 0 180 $X=29820 $Y=43420
X92 BIAS VDDA 3 pmos1v2hvt_4_CDNS_781966947810 $T=39680 51820 0 180 $X=35060 $Y=43420
X93 8 GNDA 9 nmos1v2hvt_4_CDNS_781966947815 $T=52370 5805 0 0 $X=51750 $Y=5085
X94 9 GNDA PRN nmos1v2hvt_4_CDNS_781966947815 $T=53810 5805 0 0 $X=53190 $Y=5085
X95 PDN VDDA BIAS pmos1v2hvt_4_CDNS_781966947819 $T=9520 51820 1 0 $X=8900 $Y=49420
X96 1 GNDA GNDA nmos1v2hvt_4_CDNS_7819669478112 $T=35920 6615 0 0 $X=35300 $Y=5895
X97 7 1 GNDA nmos1v2hvt_4_CDNS_7819669478112 $T=35920 9450 0 0 $X=35300 $Y=8730
X98 4 GNDA PRN_TRIGGER nmos1v2hvt_4_CDNS_7819669478115 $T=21640 6615 0 0 $X=21020 $Y=5895
X99 4 GNDA 4 nmos1v2hvt_4_CDNS_7819669478115 $T=26880 6615 0 0 $X=26260 $Y=5895
X100 PRN_TRIGGER VDDA 8 pmos1v2hvt_4_CDNS_7819669478119 $T=50390 11870 1 0 $X=49770 $Y=9470
X101 8 VDDA 9 pmos1v2hvt_4_CDNS_7819669478121 $T=52130 11875 1 0 $X=51510 $Y=9465
X102 9 VDDA PRN pmos1v2hvt_4_CDNS_7819669478121 $T=53570 11875 1 0 $X=52950 $Y=9465
X103 PD GNDA PRN_TRIGGER nmos1v2hvt_4_CDNS_7819669478123 $T=16530 5805 0 0 $X=15910 $Y=5085
X104 PD GNDA 4 nmos1v2hvt_4_CDNS_7819669478123 $T=18270 5805 0 0 $X=17650 $Y=5085
X105 1 3 4 VDDA pmos1v2hvt_4_CDNS_7819669478125 $T=11670 17330 0 0 $X=11050 $Y=16610
X106 VREF 3 PRN_TRIGGER VDDA pmos1v2hvt_4_CDNS_7819669478125 $T=11670 35130 1 0 $X=11050 $Y=26730
X107 VREF 3 PRN_TRIGGER VDDA pmos1v2hvt_4_CDNS_7819669478125 $T=14910 17330 0 0 $X=14290 $Y=16610
X108 1 3 4 VDDA pmos1v2hvt_4_CDNS_7819669478125 $T=14910 35130 1 0 $X=14290 $Y=26730
X109 1 3 4 VDDA pmos1v2hvt_4_CDNS_7819669478125 $T=18150 17330 0 0 $X=17530 $Y=16610
X110 VREF 3 PRN_TRIGGER VDDA pmos1v2hvt_4_CDNS_7819669478125 $T=18150 35130 1 0 $X=17530 $Y=26730
X111 VREF 3 PRN_TRIGGER VDDA pmos1v2hvt_4_CDNS_7819669478125 $T=21390 17330 0 0 $X=20770 $Y=16610
X112 1 3 4 VDDA pmos1v2hvt_4_CDNS_7819669478125 $T=21390 35130 1 0 $X=20770 $Y=26730
X113 1 3 4 VDDA pmos1v2hvt_4_CDNS_7819669478125 $T=24630 17330 0 0 $X=24010 $Y=16610
X114 VREF 3 PRN_TRIGGER VDDA pmos1v2hvt_4_CDNS_7819669478125 $T=24630 35130 1 0 $X=24010 $Y=26730
X115 1 3 4 VDDA pmos1v2hvt_4_CDNS_7819669478125 $T=27870 17330 0 0 $X=27250 $Y=16610
X116 VREF 3 PRN_TRIGGER VDDA pmos1v2hvt_4_CDNS_7819669478125 $T=27870 35130 1 0 $X=27250 $Y=26730
X117 VREF 3 PRN_TRIGGER VDDA pmos1v2hvt_4_CDNS_7819669478125 $T=31110 17330 0 0 $X=30490 $Y=16610
X118 1 3 4 VDDA pmos1v2hvt_4_CDNS_7819669478125 $T=31110 35130 1 0 $X=30490 $Y=26730
X119 1 3 4 VDDA pmos1v2hvt_4_CDNS_7819669478125 $T=34350 17330 0 0 $X=33730 $Y=16610
X120 VREF 3 PRN_TRIGGER VDDA pmos1v2hvt_4_CDNS_7819669478125 $T=34350 35130 1 0 $X=33730 $Y=26730
X121 VREF 3 PRN_TRIGGER VDDA pmos1v2hvt_4_CDNS_7819669478125 $T=37590 17330 0 0 $X=36970 $Y=16610
X122 1 3 4 VDDA pmos1v2hvt_4_CDNS_7819669478125 $T=37590 35130 1 0 $X=36970 $Y=26730
X123 1 3 4 VDDA pmos1v2hvt_4_CDNS_7819669478125 $T=40830 17330 0 0 $X=40210 $Y=16610
X124 VREF 3 PRN_TRIGGER VDDA pmos1v2hvt_4_CDNS_7819669478125 $T=40830 35130 1 0 $X=40210 $Y=26730
X125 VDDA pmos1v2hvt_4_CDNS_7819669478128 $T=9930 17330 0 0 $X=9310 $Y=16610
X126 VDDA pmos1v2hvt_4_CDNS_7819669478128 $T=9930 35130 1 0 $X=9310 $Y=26730
X127 VDDA pmos1v2hvt_4_CDNS_7819669478128 $T=44070 17330 0 0 $X=43450 $Y=16610
X128 VDDA pmos1v2hvt_4_CDNS_7819669478128 $T=44070 35130 1 0 $X=43450 $Y=26730
X129 VDDA pmos1v2hvt_4_CDNS_7819669478129 $T=12480 51820 1 0 $X=11860 $Y=43420
X130 VDDA pmos1v2hvt_4_CDNS_7819669478129 $T=40920 51820 1 0 $X=40300 $Y=43420
X131 PRN_TRIGGER GNDA 8 nmos1v2hvt_4_CDNS_7819669478132 $T=50390 5805 0 0 $X=49770 $Y=5085
.ends BG_STARTUP_fL2
