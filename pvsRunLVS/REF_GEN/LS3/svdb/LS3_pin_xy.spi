* +++++++++++++++++++++++++++++++++++++++++++++++++++++++++ *
* CDL Netlist:                                              *
*                                                           *
* Cell Name  : LS3                                          *
* Netlisted  : Tue Jul 28 08:52:24 2026                     *
* PVS Version: 24.11-s045 Mon Jan 27 22:18:54 PST 2025      *
* +++++++++++++++++++++++++++++++++++++++++++++++++++++++++ *
*.LDD
*.DEVTMPLT 0 MN(nmos1v2hvt) NMOS1V2HVT NDIFF(D) NGATE(G) NDIFF(S) PW1V2(B)
*.DEVTMPLT 1 MP(pmos1v2hvt) PMOS1V2HVT PDIFF(D) PGATE(G) PDIFF(S) NW1V2(B)

* +++++++++++++++++++++++++++++++++++++++++++++++++++++++++ *
* Sub cell: M1_M2_CDNS_785228740690                         *
* +++++++++++++++++++++++++++++++++++++++++++++++++++++++++ *
.subckt M1_M2_CDNS_785228740690 1
** N=1 EP=1 FDC=0
.ends M1_M2_CDNS_785228740690

* +++++++++++++++++++++++++++++++++++++++++++++++++++++++++ *
* Sub cell: M1_M2_CDNS_785228740691                         *
* +++++++++++++++++++++++++++++++++++++++++++++++++++++++++ *
.subckt M1_M2_CDNS_785228740691 1
** N=1 EP=1 FDC=0
.ends M1_M2_CDNS_785228740691

* +++++++++++++++++++++++++++++++++++++++++++++++++++++++++ *
* Sub cell: LS                                              *
* +++++++++++++++++++++++++++++++++++++++++++++++++++++++++ *
.subckt LS 1 2 3 4 5 6 7
** N=8 EP=7 FDC=6
M0 5 1 8 5 nmos1v2hvt L=1.8e-07 W=2.6e-07 AD=7.8e-14 AS=7.8e-14 PD=8.6e-07 PS=8.6e-07 m=1 $X=375 $Y=730 $dt=0
M1 7 1 2 7 nmos1v2hvt L=1.1e-07 W=2.6e-07 AD=8.84e-14 AS=7.8e-14 PD=9.4e-07 PS=8.6e-07 m=1 $X=1595 $Y=390 $dt=0
M2 3 8 7 7 nmos1v2hvt L=1.1e-07 W=2.6e-07 AD=7.8e-14 AS=8.84e-14 PD=8.6e-07 PS=9.4e-07 m=1 $X=2045 $Y=390 $dt=0
M3 4 1 8 4 pmos1v2hvt L=1.8e-07 W=2.6e-07 AD=7.8e-14 AS=7.8e-14 PD=8.6e-07 PS=8.6e-07 m=1 $X=410 $Y=1910 $dt=1
M4 6 3 2 6 pmos1v2hvt L=1.97e-06 W=1.5e-07 AD=1.981e-13 AS=1.216e-13 PD=2.63e-06 PS=1.61e-06 m=1 $X=2225 $Y=1480 $dt=1
M5 6 2 3 6 pmos1v2hvt L=1.97e-06 W=1.5e-07 AD=1.981e-13 AS=8.26e-14 PD=2.63e-06 PS=1.09e-06 m=1 $X=2225 $Y=2260 $dt=1
.ends LS

* +++++++++++++++++++++++++++++++++++++++++++++++++++++++++ *
* Sub cell: LS3                                             *
* +++++++++++++++++++++++++++++++++++++++++++++++++++++++++ *
.subckt LS3 7 6 11 8 3 13 10 5 2 1
** N=13 EP=10 FDC=18
X0 1 M1_M2_CDNS_785228740690 $T=290 9605 1 180 $X=10 $Y=9295
X1 2 M1_M2_CDNS_785228740690 $T=6145 9605 0 0 $X=5865 $Y=9295
X2 1 M1_M2_CDNS_785228740691 $T=1230 3415 1 180 $X=775 $Y=3105
X3 2 M1_M2_CDNS_785228740691 $T=5205 3415 0 0 $X=4750 $Y=3105
X4 3 4 5 1 6 2 7 LS $T=860 415 0 0 $X=635 $Y=165
X5 8 9 10 1 6 2 7 LS $T=860 6415 1 0 $X=635 $Y=3365
X6 11 12 13 1 6 2 7 LS $T=860 6815 0 0 $X=635 $Y=6565
.ends LS3
