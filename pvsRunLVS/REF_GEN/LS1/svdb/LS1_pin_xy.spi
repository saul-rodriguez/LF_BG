* +++++++++++++++++++++++++++++++++++++++++++++++++++++++++ *
* CDL Netlist:                                              *
*                                                           *
* Cell Name  : LS1                                          *
* Netlisted  : Thu Jul 30 10:51:08 2026                     *
* PVS Version: 24.11-s045 Mon Jan 27 22:18:54 PST 2025      *
* +++++++++++++++++++++++++++++++++++++++++++++++++++++++++ *
*.LDD
*.DEVTMPLT 0 MN(nmos1v2hvt) NMOS1V2HVT NDIFF(D) NGATE(G) NDIFF(S) PW1V2(B)
*.DEVTMPLT 1 MP(pmos1v2hvt) PMOS1V2HVT PDIFF(D) PGATE(G) PDIFF(S) NW1V2(B)

* +++++++++++++++++++++++++++++++++++++++++++++++++++++++++ *
* Sub cell: LS                                              *
* +++++++++++++++++++++++++++++++++++++++++++++++++++++++++ *
.subckt LS 1 2 3 4 5 6 7
** N=8 EP=7 FDC=6
M0 5 1 8 5 nmos1v2hvt L=1.8e-07 W=2.6e-07 AD=7.8e-14 AS=7.8e-14 PD=8.6e-07 PS=8.6e-07 m=1 $X=375 $Y=730 $dt=0
M1 7 1 2 7 nmos1v2hvt L=1.1e-07 W=2.6e-07 AD=8.84e-14 AS=7.8e-14 PD=9.4e-07 PS=8.6e-07 m=1 $X=1595 $Y=390 $dt=0
M2 3 8 7 7 nmos1v2hvt L=1.1e-07 W=2.6e-07 AD=7.8e-14 AS=8.84e-14 PD=8.6e-07 PS=9.4e-07 m=1 $X=2045 $Y=390 $dt=0
M3 4 1 8 4 pmos1v2hvt L=1.8e-07 W=2.6e-07 AD=7.8e-14 AS=7.8e-14 PD=8.6e-07 PS=8.6e-07 m=1 $X=410 $Y=1910 $dt=1
M4 6 3 2 6 pmos1v2hvt L=1.97e-06 W=1.5e-07 AD=1.981e-13 AS=1.216e-13 PD=2.63e-06 PS=1.61e-06 m=1 $X=2225 $Y=1480 $dt=1
M5 6 2 3 6 pmos1v2hvt L=1.97e-06 W=1.5e-07 AD=1.981e-13 AS=8.26e-14 PD=2.63e-06 PS=1.09e-06 m=1 $X=2225 $Y=2260 $dt=1
.ends LS

* +++++++++++++++++++++++++++++++++++++++++++++++++++++++++ *
* Sub cell: LS1                                             *
* +++++++++++++++++++++++++++++++++++++++++++++++++++++++++ *
.subckt LS1 7 5 1 3 6 4
** N=7 EP=6 FDC=6
X0 1 2 3 4 5 6 7 LS $T=225 250 0 0 $X=0 $Y=0
.ends LS1
