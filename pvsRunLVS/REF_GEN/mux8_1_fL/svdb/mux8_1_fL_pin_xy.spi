* +++++++++++++++++++++++++++++++++++++++++++++++++++++++++ *
* CDL Netlist:                                              *
*                                                           *
* Cell Name  : mux8_1_fL                                    *
* Netlisted  : Mon Jun 15 12:44:19 2026                     *
* PVS Version: 24.11-s045 Mon Jan 27 22:18:54 PST 2025      *
* +++++++++++++++++++++++++++++++++++++++++++++++++++++++++ *
*.LDD
*.DEVTMPLT 0 MN(nmos1v2hvt) NMOS1V2HVT NDIFF(D) NGATE(G) NDIFF(S) PW1V2(B)

* +++++++++++++++++++++++++++++++++++++++++++++++++++++++++ *
* Sub cell: M1_M2_CDNS_781527455600                         *
* +++++++++++++++++++++++++++++++++++++++++++++++++++++++++ *
.subckt M1_M2_CDNS_781527455600 1
** N=1 EP=1 FDC=0
.ends M1_M2_CDNS_781527455600

* +++++++++++++++++++++++++++++++++++++++++++++++++++++++++ *
* Sub cell: M2_M3_CDNS_781527455601                         *
* +++++++++++++++++++++++++++++++++++++++++++++++++++++++++ *
.subckt M2_M3_CDNS_781527455601 1
** N=1 EP=1 FDC=0
.ends M2_M3_CDNS_781527455601

* +++++++++++++++++++++++++++++++++++++++++++++++++++++++++ *
* Sub cell: Contact_CDNS_781527455601                       *
* +++++++++++++++++++++++++++++++++++++++++++++++++++++++++ *
.subckt Contact_CDNS_781527455601 1 2
** N=2 EP=2 FDC=0
.ends Contact_CDNS_781527455601

* +++++++++++++++++++++++++++++++++++++++++++++++++++++++++ *
* Sub cell: Contact_CDNS_781527455602                       *
* +++++++++++++++++++++++++++++++++++++++++++++++++++++++++ *
.subckt Contact_CDNS_781527455602 1
** N=1 EP=1 FDC=0
.ends Contact_CDNS_781527455602

* +++++++++++++++++++++++++++++++++++++++++++++++++++++++++ *
* Sub cell: nmos1v2hvt_4_CDNS_781527455600                  *
* +++++++++++++++++++++++++++++++++++++++++++++++++++++++++ *
.subckt nmos1v2hvt_4_CDNS_781527455600 1 2 3 4
** N=4 EP=4 FDC=1
X0 2 4 Contact_CDNS_781527455601 $T=-245 130 0 0 $X=-245 $Y=0
X1 3 4 Contact_CDNS_781527455601 $T=1095 130 0 0 $X=1095 $Y=0
X2 2 Contact_CDNS_781527455602 $T=-275 140 0 0 $X=-275 $Y=0
X3 3 Contact_CDNS_781527455602 $T=1065 140 0 0 $X=1065 $Y=0
M0 3 1 2 4 nmos1v2hvt L=1e-06 W=1e-05 AD=3e-12 AS=3e-12 PD=1.06e-05 PS=1.06e-05 m=1 $X=0 $Y=0 $dt=0
.ends nmos1v2hvt_4_CDNS_781527455600

* +++++++++++++++++++++++++++++++++++++++++++++++++++++++++ *
* Sub cell: mux8_1_fL                                       *
* +++++++++++++++++++++++++++++++++++++++++++++++++++++++++ *
.subckt mux8_1_fL 1 2 3 4 5 6 7 8 9 11
+ 10 12 13 14 15 16 17 18
** N=18 EP=18 FDC=8
X0 1 M1_M2_CDNS_781527455600 $T=2015 11725 0 0 $X=1735 $Y=11415
X1 2 M1_M2_CDNS_781527455600 $T=4215 11725 0 0 $X=3935 $Y=11415
X2 3 M1_M2_CDNS_781527455600 $T=6415 11725 0 0 $X=6135 $Y=11415
X3 4 M1_M2_CDNS_781527455600 $T=8615 11725 0 0 $X=8335 $Y=11415
X4 5 M1_M2_CDNS_781527455600 $T=10815 11725 0 0 $X=10535 $Y=11415
X5 6 M1_M2_CDNS_781527455600 $T=13015 11725 0 0 $X=12735 $Y=11415
X6 7 M1_M2_CDNS_781527455600 $T=15215 11725 0 0 $X=14935 $Y=11415
X7 8 M1_M2_CDNS_781527455600 $T=17415 11725 0 0 $X=17135 $Y=11415
X8 1 M2_M3_CDNS_781527455601 $T=2015 11725 0 0 $X=1685 $Y=11375
X9 2 M2_M3_CDNS_781527455601 $T=4215 11725 0 0 $X=3885 $Y=11375
X10 3 M2_M3_CDNS_781527455601 $T=6415 11725 0 0 $X=6085 $Y=11375
X11 4 M2_M3_CDNS_781527455601 $T=8615 11725 0 0 $X=8285 $Y=11375
X12 5 M2_M3_CDNS_781527455601 $T=10815 11725 0 0 $X=10485 $Y=11375
X13 6 M2_M3_CDNS_781527455601 $T=13015 11725 0 0 $X=12685 $Y=11375
X14 7 M2_M3_CDNS_781527455601 $T=15215 11725 0 0 $X=14885 $Y=11375
X15 8 M2_M3_CDNS_781527455601 $T=17415 11725 0 0 $X=17085 $Y=11375
X16 1 9 10 11 nmos1v2hvt_4_CDNS_781527455600 $T=1515 1315 0 0 $X=915 $Y=915
X17 2 9 12 11 nmos1v2hvt_4_CDNS_781527455600 $T=3715 1315 0 0 $X=3115 $Y=915
X18 3 9 13 11 nmos1v2hvt_4_CDNS_781527455600 $T=5915 1315 0 0 $X=5315 $Y=915
X19 4 9 14 11 nmos1v2hvt_4_CDNS_781527455600 $T=8115 1315 0 0 $X=7515 $Y=915
X20 5 9 15 11 nmos1v2hvt_4_CDNS_781527455600 $T=10315 1315 0 0 $X=9715 $Y=915
X21 6 9 16 11 nmos1v2hvt_4_CDNS_781527455600 $T=12515 1315 0 0 $X=11915 $Y=915
X22 7 9 17 11 nmos1v2hvt_4_CDNS_781527455600 $T=14715 1315 0 0 $X=14115 $Y=915
X23 8 9 18 11 nmos1v2hvt_4_CDNS_781527455600 $T=16915 1315 0 0 $X=16315 $Y=915
.ends mux8_1_fL
