* +++++++++++++++++++++++++++++++++++++++++++++++++++++++++ *
* CDL Netlist:                                              *
*                                                           *
* Cell Name  : mux8_1_fL                                    *
* Netlisted  : Mon Jun 15 12:44:19 2026                     *
* PVS Version: 24.11-s045 Mon Jan 27 22:18:54 PST 2025      *
* +++++++++++++++++++++++++++++++++++++++++++++++++++++++++ *
*.LDD
*.DEVTMPLT 0 MN(nmos1v2hvt) NMOS1V2HVT NDIFF(D) NGATE(G) NDIFF(S) PW1V2(B)

* +++++++++++++++++++++++++++++++++++++++++++++++++++++++++ *
* Sub cell: nmos1v2hvt_4_CDNS_781527455600                  *
* +++++++++++++++++++++++++++++++++++++++++++++++++++++++++ *
.subckt nmos1v2hvt_4_CDNS_781527455600 1 2 3 4
** N=4 EP=4 FDC=1
M0 3 1 2 4 nmos1v2hvt L=1e-06 W=1e-05 AD=3e-12 AS=3e-12 PD=1.06e-05 PS=1.06e-05 m=1 $X=0 $Y=0 $dt=0
.ends nmos1v2hvt_4_CDNS_781527455600

* +++++++++++++++++++++++++++++++++++++++++++++++++++++++++ *
* Sub cell: mux8_1_fL                                       *
* +++++++++++++++++++++++++++++++++++++++++++++++++++++++++ *
.subckt mux8_1_fL A0 A1 A2 A3 A4 A5 A6 A7 COM GNDA
+ IN0 IN1 IN2 IN3 IN4 IN5 IN6 IN7
** N=18 EP=18 FDC=8
X16 A0 COM IN0 GNDA nmos1v2hvt_4_CDNS_781527455600 $T=1515 1315 0 0 $X=915 $Y=915
X17 A1 COM IN1 GNDA nmos1v2hvt_4_CDNS_781527455600 $T=3715 1315 0 0 $X=3115 $Y=915
X18 A2 COM IN2 GNDA nmos1v2hvt_4_CDNS_781527455600 $T=5915 1315 0 0 $X=5315 $Y=915
X19 A3 COM IN3 GNDA nmos1v2hvt_4_CDNS_781527455600 $T=8115 1315 0 0 $X=7515 $Y=915
X20 A4 COM IN4 GNDA nmos1v2hvt_4_CDNS_781527455600 $T=10315 1315 0 0 $X=9715 $Y=915
X21 A5 COM IN5 GNDA nmos1v2hvt_4_CDNS_781527455600 $T=12515 1315 0 0 $X=11915 $Y=915
X22 A6 COM IN6 GNDA nmos1v2hvt_4_CDNS_781527455600 $T=14715 1315 0 0 $X=14115 $Y=915
X23 A7 COM IN7 GNDA nmos1v2hvt_4_CDNS_781527455600 $T=16915 1315 0 0 $X=16315 $Y=915
.ends mux8_1_fL
