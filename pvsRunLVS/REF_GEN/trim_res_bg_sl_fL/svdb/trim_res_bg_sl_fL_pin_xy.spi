* +++++++++++++++++++++++++++++++++++++++++++++++++++++++++ *
* CDL Netlist:                                              *
*                                                           *
* Cell Name  : trim_res_bg_sl_fL                            *
* Netlisted  : Sun Jun 21 02:01:59 2026                     *
* PVS Version: 24.11-s045 Mon Jan 27 22:18:54 PST 2025      *
* +++++++++++++++++++++++++++++++++++++++++++++++++++++++++ *
*.LDD
*.DEVTMPLT 0 R(rnpolyh) RNPOLYHNW1V2 POLYG3(POS) POLYG3(NEG) NW1V2(SUB)

* +++++++++++++++++++++++++++++++++++++++++++++++++++++++++ *
* Sub cell: Contact_CDNS_782007315131                       *
* +++++++++++++++++++++++++++++++++++++++++++++++++++++++++ *
.subckt Contact_CDNS_782007315131 1
** N=1 EP=1 FDC=0
.ends Contact_CDNS_782007315131

* +++++++++++++++++++++++++++++++++++++++++++++++++++++++++ *
* Sub cell: rnpolyh_CDNS_782007315130                       *
* +++++++++++++++++++++++++++++++++++++++++++++++++++++++++ *
.subckt rnpolyh_CDNS_782007315130 1 2 3 4
** N=4 EP=4 FDC=1
X0 3 Contact_CDNS_782007315131 $T=-30 -520 0 0 $X=-50 $Y=-540
X1 2 Contact_CDNS_782007315131 $T=-30 10260 0 0 $X=-50 $Y=10240
R0 3 2 37927.7 L=1e-05 W=5e-07 $[rnpolyh] $SUB=4 $X=0 $Y=0 $dt=0
.ends rnpolyh_CDNS_782007315130

* +++++++++++++++++++++++++++++++++++++++++++++++++++++++++ *
* Sub cell: rnpolyh_CDNS_782007315133                       *
* +++++++++++++++++++++++++++++++++++++++++++++++++++++++++ *
.subckt rnpolyh_CDNS_782007315133 1 2
** N=2 EP=2 FDC=1
X0 2 Contact_CDNS_782007315131 $T=-30 -520 0 0 $X=-50 $Y=-540
X1 2 Contact_CDNS_782007315131 $T=-30 10260 0 0 $X=-50 $Y=10240
R0 2 2 37927.7 L=1e-05 W=5e-07 $[rnpolyh] $SUB=2 $X=0 $Y=0 $dt=0
.ends rnpolyh_CDNS_782007315133

* +++++++++++++++++++++++++++++++++++++++++++++++++++++++++ *
* Sub cell: MASCO__Y1                                       *
* +++++++++++++++++++++++++++++++++++++++++++++++++++++++++ *
.subckt MASCO__Y1 1 2 3 4 5 6 7 8 9 10
+ 11 12
** N=12 EP=12 FDC=0
X0 1 Contact_CDNS_782007315131 $T=20 20 0 0 $X=0 $Y=0
X1 2 Contact_CDNS_782007315131 $T=770 20 0 0 $X=750 $Y=0
X2 3 Contact_CDNS_782007315131 $T=1520 20 0 0 $X=1500 $Y=0
X3 4 Contact_CDNS_782007315131 $T=2270 20 0 0 $X=2250 $Y=0
X4 5 Contact_CDNS_782007315131 $T=3020 20 0 0 $X=3000 $Y=0
X5 6 Contact_CDNS_782007315131 $T=3770 20 0 0 $X=3750 $Y=0
X6 7 Contact_CDNS_782007315131 $T=4520 20 0 0 $X=4500 $Y=0
X7 8 Contact_CDNS_782007315131 $T=5270 20 0 0 $X=5250 $Y=0
X8 9 Contact_CDNS_782007315131 $T=6020 20 0 0 $X=6000 $Y=0
X9 10 Contact_CDNS_782007315131 $T=6770 20 0 0 $X=6750 $Y=0
X10 11 Contact_CDNS_782007315131 $T=7520 20 0 0 $X=7500 $Y=0
X11 12 Contact_CDNS_782007315131 $T=8270 20 0 0 $X=8250 $Y=0
.ends MASCO__Y1

* +++++++++++++++++++++++++++++++++++++++++++++++++++++++++ *
* Sub cell: trim_res_bg_sl_fL                               *
* +++++++++++++++++++++++++++++++++++++++++++++++++++++++++ *
.subckt trim_res_bg_sl_fL 15 14 6 5 7 8 9 10 11 12
+ 13
** N=99 EP=11 FDC=97
X0 1 Contact_CDNS_782007315131 $T=64890 1140 0 0 $X=64870 $Y=1120
X1 2 Contact_CDNS_782007315131 $T=64890 11920 0 0 $X=64870 $Y=11900
X2 3 Contact_CDNS_782007315131 $T=65640 1140 0 0 $X=65620 $Y=1120
X3 2 Contact_CDNS_782007315131 $T=65640 11920 0 0 $X=65620 $Y=11900
X4 4 5 3 6 rnpolyh_CDNS_782007315130 $T=66420 1660 0 0 $X=66170 $Y=920
X5 4 7 5 6 rnpolyh_CDNS_782007315130 $T=67670 11660 0 180 $X=66920 $Y=920
X6 4 8 7 6 rnpolyh_CDNS_782007315130 $T=67920 1660 0 0 $X=67670 $Y=920
X7 4 9 8 6 rnpolyh_CDNS_782007315130 $T=68670 11660 1 0 $X=68420 $Y=920
X8 4 10 9 6 rnpolyh_CDNS_782007315130 $T=69420 1660 0 0 $X=69170 $Y=920
X9 4 11 10 6 rnpolyh_CDNS_782007315130 $T=70170 11660 1 0 $X=69920 $Y=920
X10 4 12 11 6 rnpolyh_CDNS_782007315130 $T=70920 1660 0 0 $X=70670 $Y=920
X11 4 13 12 6 rnpolyh_CDNS_782007315130 $T=71670 11660 1 0 $X=71420 $Y=920
X12 4 14 13 6 rnpolyh_CDNS_782007315130 $T=72420 1660 0 0 $X=72170 $Y=920
X13 4 6 rnpolyh_CDNS_782007315133 $T=1170 1660 0 0 $X=920 $Y=920
X14 4 6 rnpolyh_CDNS_782007315133 $T=73170 1660 0 0 $X=72920 $Y=920
X15 15 16 16 17 17 18 18 19 19 20
+ 20 21 MASCO__Y1 $T=1870 1120 0 0 $X=1870 $Y=1120
X16 22 22 23 23 24 24 25 25 26 26
+ 27 27 MASCO__Y1 $T=1870 11900 0 0 $X=1870 $Y=11900
X17 21 28 28 29 29 30 30 31 31 32
+ 32 33 MASCO__Y1 $T=10870 1120 0 0 $X=10870 $Y=1120
X18 34 34 35 35 36 36 37 37 38 38
+ 39 39 MASCO__Y1 $T=10870 11900 0 0 $X=10870 $Y=11900
X19 33 40 40 41 41 42 42 43 43 44
+ 44 45 MASCO__Y1 $T=19870 1120 0 0 $X=19870 $Y=1120
X20 46 46 47 47 48 48 49 49 50 50
+ 51 51 MASCO__Y1 $T=19870 11900 0 0 $X=19870 $Y=11900
X21 45 52 52 53 53 54 54 55 55 56
+ 56 57 MASCO__Y1 $T=28870 1120 0 0 $X=28870 $Y=1120
X22 58 58 59 59 60 60 61 61 62 62
+ 63 63 MASCO__Y1 $T=28870 11900 0 0 $X=28870 $Y=11900
X23 57 64 64 65 65 66 66 67 67 68
+ 68 69 MASCO__Y1 $T=37870 1120 0 0 $X=37870 $Y=1120
X24 70 70 71 71 72 72 73 73 74 74
+ 75 75 MASCO__Y1 $T=37870 11900 0 0 $X=37870 $Y=11900
X25 69 76 76 77 77 78 78 79 79 80
+ 80 81 MASCO__Y1 $T=46870 1120 0 0 $X=46870 $Y=1120
X26 82 82 83 83 84 84 85 85 86 86
+ 87 87 MASCO__Y1 $T=46870 11900 0 0 $X=46870 $Y=11900
X27 81 88 88 89 89 90 90 91 91 92
+ 92 1 MASCO__Y1 $T=55870 1120 0 0 $X=55870 $Y=1120
X28 93 93 94 94 95 95 96 96 97 97
+ 98 98 MASCO__Y1 $T=55870 11900 0 0 $X=55870 $Y=11900
R0 15 22 37927.7 L=1e-05 W=5e-07 $[rnpolyh] $SUB=6 $X=1920 $Y=1660 $dt=0
R1 16 22 37927.7 L=1e-05 W=5e-07 $[rnpolyh] $SUB=6 $X=2670 $Y=1660 $dt=0
R2 16 23 37927.7 L=1e-05 W=5e-07 $[rnpolyh] $SUB=6 $X=3420 $Y=1660 $dt=0
R3 17 23 37927.7 L=1e-05 W=5e-07 $[rnpolyh] $SUB=6 $X=4170 $Y=1660 $dt=0
R4 17 24 37927.7 L=1e-05 W=5e-07 $[rnpolyh] $SUB=6 $X=4920 $Y=1660 $dt=0
R5 18 24 37927.7 L=1e-05 W=5e-07 $[rnpolyh] $SUB=6 $X=5670 $Y=1660 $dt=0
R6 18 25 37927.7 L=1e-05 W=5e-07 $[rnpolyh] $SUB=6 $X=6420 $Y=1660 $dt=0
R7 19 25 37927.7 L=1e-05 W=5e-07 $[rnpolyh] $SUB=6 $X=7170 $Y=1660 $dt=0
R8 19 26 37927.7 L=1e-05 W=5e-07 $[rnpolyh] $SUB=6 $X=7920 $Y=1660 $dt=0
R9 20 26 37927.7 L=1e-05 W=5e-07 $[rnpolyh] $SUB=6 $X=8670 $Y=1660 $dt=0
R10 20 27 37927.7 L=1e-05 W=5e-07 $[rnpolyh] $SUB=6 $X=9420 $Y=1660 $dt=0
R11 21 27 37927.7 L=1e-05 W=5e-07 $[rnpolyh] $SUB=6 $X=10170 $Y=1660 $dt=0
R12 21 34 37927.7 L=1e-05 W=5e-07 $[rnpolyh] $SUB=6 $X=10920 $Y=1660 $dt=0
R13 28 34 37927.7 L=1e-05 W=5e-07 $[rnpolyh] $SUB=6 $X=11670 $Y=1660 $dt=0
R14 28 35 37927.7 L=1e-05 W=5e-07 $[rnpolyh] $SUB=6 $X=12420 $Y=1660 $dt=0
R15 29 35 37927.7 L=1e-05 W=5e-07 $[rnpolyh] $SUB=6 $X=13170 $Y=1660 $dt=0
R16 29 36 37927.7 L=1e-05 W=5e-07 $[rnpolyh] $SUB=6 $X=13920 $Y=1660 $dt=0
R17 30 36 37927.7 L=1e-05 W=5e-07 $[rnpolyh] $SUB=6 $X=14670 $Y=1660 $dt=0
R18 30 37 37927.7 L=1e-05 W=5e-07 $[rnpolyh] $SUB=6 $X=15420 $Y=1660 $dt=0
R19 31 37 37927.7 L=1e-05 W=5e-07 $[rnpolyh] $SUB=6 $X=16170 $Y=1660 $dt=0
R20 31 38 37927.7 L=1e-05 W=5e-07 $[rnpolyh] $SUB=6 $X=16920 $Y=1660 $dt=0
R21 32 38 37927.7 L=1e-05 W=5e-07 $[rnpolyh] $SUB=6 $X=17670 $Y=1660 $dt=0
R22 32 39 37927.7 L=1e-05 W=5e-07 $[rnpolyh] $SUB=6 $X=18420 $Y=1660 $dt=0
R23 33 39 37927.7 L=1e-05 W=5e-07 $[rnpolyh] $SUB=6 $X=19170 $Y=1660 $dt=0
R24 33 46 37927.7 L=1e-05 W=5e-07 $[rnpolyh] $SUB=6 $X=19920 $Y=1660 $dt=0
R25 40 46 37927.7 L=1e-05 W=5e-07 $[rnpolyh] $SUB=6 $X=20670 $Y=1660 $dt=0
R26 40 47 37927.7 L=1e-05 W=5e-07 $[rnpolyh] $SUB=6 $X=21420 $Y=1660 $dt=0
R27 41 47 37927.7 L=1e-05 W=5e-07 $[rnpolyh] $SUB=6 $X=22170 $Y=1660 $dt=0
R28 41 48 37927.7 L=1e-05 W=5e-07 $[rnpolyh] $SUB=6 $X=22920 $Y=1660 $dt=0
R29 42 48 37927.7 L=1e-05 W=5e-07 $[rnpolyh] $SUB=6 $X=23670 $Y=1660 $dt=0
R30 42 49 37927.7 L=1e-05 W=5e-07 $[rnpolyh] $SUB=6 $X=24420 $Y=1660 $dt=0
R31 43 49 37927.7 L=1e-05 W=5e-07 $[rnpolyh] $SUB=6 $X=25170 $Y=1660 $dt=0
R32 43 50 37927.7 L=1e-05 W=5e-07 $[rnpolyh] $SUB=6 $X=25920 $Y=1660 $dt=0
R33 44 50 37927.7 L=1e-05 W=5e-07 $[rnpolyh] $SUB=6 $X=26670 $Y=1660 $dt=0
R34 44 51 37927.7 L=1e-05 W=5e-07 $[rnpolyh] $SUB=6 $X=27420 $Y=1660 $dt=0
R35 45 51 37927.7 L=1e-05 W=5e-07 $[rnpolyh] $SUB=6 $X=28170 $Y=1660 $dt=0
R36 45 58 37927.7 L=1e-05 W=5e-07 $[rnpolyh] $SUB=6 $X=28920 $Y=1660 $dt=0
R37 52 58 37927.7 L=1e-05 W=5e-07 $[rnpolyh] $SUB=6 $X=29670 $Y=1660 $dt=0
R38 52 59 37927.7 L=1e-05 W=5e-07 $[rnpolyh] $SUB=6 $X=30420 $Y=1660 $dt=0
R39 53 59 37927.7 L=1e-05 W=5e-07 $[rnpolyh] $SUB=6 $X=31170 $Y=1660 $dt=0
R40 53 60 37927.7 L=1e-05 W=5e-07 $[rnpolyh] $SUB=6 $X=31920 $Y=1660 $dt=0
R41 54 60 37927.7 L=1e-05 W=5e-07 $[rnpolyh] $SUB=6 $X=32670 $Y=1660 $dt=0
R42 54 61 37927.7 L=1e-05 W=5e-07 $[rnpolyh] $SUB=6 $X=33420 $Y=1660 $dt=0
R43 55 61 37927.7 L=1e-05 W=5e-07 $[rnpolyh] $SUB=6 $X=34170 $Y=1660 $dt=0
R44 55 62 37927.7 L=1e-05 W=5e-07 $[rnpolyh] $SUB=6 $X=34920 $Y=1660 $dt=0
R45 56 62 37927.7 L=1e-05 W=5e-07 $[rnpolyh] $SUB=6 $X=35670 $Y=1660 $dt=0
R46 56 63 37927.7 L=1e-05 W=5e-07 $[rnpolyh] $SUB=6 $X=36420 $Y=1660 $dt=0
R47 57 63 37927.7 L=1e-05 W=5e-07 $[rnpolyh] $SUB=6 $X=37170 $Y=1660 $dt=0
R48 57 70 37927.7 L=1e-05 W=5e-07 $[rnpolyh] $SUB=6 $X=37920 $Y=1660 $dt=0
R49 64 70 37927.7 L=1e-05 W=5e-07 $[rnpolyh] $SUB=6 $X=38670 $Y=1660 $dt=0
R50 64 71 37927.7 L=1e-05 W=5e-07 $[rnpolyh] $SUB=6 $X=39420 $Y=1660 $dt=0
R51 65 71 37927.7 L=1e-05 W=5e-07 $[rnpolyh] $SUB=6 $X=40170 $Y=1660 $dt=0
R52 65 72 37927.7 L=1e-05 W=5e-07 $[rnpolyh] $SUB=6 $X=40920 $Y=1660 $dt=0
R53 66 72 37927.7 L=1e-05 W=5e-07 $[rnpolyh] $SUB=6 $X=41670 $Y=1660 $dt=0
R54 66 73 37927.7 L=1e-05 W=5e-07 $[rnpolyh] $SUB=6 $X=42420 $Y=1660 $dt=0
R55 67 73 37927.7 L=1e-05 W=5e-07 $[rnpolyh] $SUB=6 $X=43170 $Y=1660 $dt=0
R56 67 74 37927.7 L=1e-05 W=5e-07 $[rnpolyh] $SUB=6 $X=43920 $Y=1660 $dt=0
R57 68 74 37927.7 L=1e-05 W=5e-07 $[rnpolyh] $SUB=6 $X=44670 $Y=1660 $dt=0
R58 68 75 37927.7 L=1e-05 W=5e-07 $[rnpolyh] $SUB=6 $X=45420 $Y=1660 $dt=0
R59 69 75 37927.7 L=1e-05 W=5e-07 $[rnpolyh] $SUB=6 $X=46170 $Y=1660 $dt=0
R60 69 82 37927.7 L=1e-05 W=5e-07 $[rnpolyh] $SUB=6 $X=46920 $Y=1660 $dt=0
R61 76 82 37927.7 L=1e-05 W=5e-07 $[rnpolyh] $SUB=6 $X=47670 $Y=1660 $dt=0
R62 76 83 37927.7 L=1e-05 W=5e-07 $[rnpolyh] $SUB=6 $X=48420 $Y=1660 $dt=0
R63 77 83 37927.7 L=1e-05 W=5e-07 $[rnpolyh] $SUB=6 $X=49170 $Y=1660 $dt=0
R64 77 84 37927.7 L=1e-05 W=5e-07 $[rnpolyh] $SUB=6 $X=49920 $Y=1660 $dt=0
R65 78 84 37927.7 L=1e-05 W=5e-07 $[rnpolyh] $SUB=6 $X=50670 $Y=1660 $dt=0
R66 78 85 37927.7 L=1e-05 W=5e-07 $[rnpolyh] $SUB=6 $X=51420 $Y=1660 $dt=0
R67 79 85 37927.7 L=1e-05 W=5e-07 $[rnpolyh] $SUB=6 $X=52170 $Y=1660 $dt=0
R68 79 86 37927.7 L=1e-05 W=5e-07 $[rnpolyh] $SUB=6 $X=52920 $Y=1660 $dt=0
R69 80 86 37927.7 L=1e-05 W=5e-07 $[rnpolyh] $SUB=6 $X=53670 $Y=1660 $dt=0
R70 80 87 37927.7 L=1e-05 W=5e-07 $[rnpolyh] $SUB=6 $X=54420 $Y=1660 $dt=0
R71 81 87 37927.7 L=1e-05 W=5e-07 $[rnpolyh] $SUB=6 $X=55170 $Y=1660 $dt=0
R72 81 93 37927.7 L=1e-05 W=5e-07 $[rnpolyh] $SUB=6 $X=55920 $Y=1660 $dt=0
R73 88 93 37927.7 L=1e-05 W=5e-07 $[rnpolyh] $SUB=6 $X=56670 $Y=1660 $dt=0
R74 88 94 37927.7 L=1e-05 W=5e-07 $[rnpolyh] $SUB=6 $X=57420 $Y=1660 $dt=0
R75 89 94 37927.7 L=1e-05 W=5e-07 $[rnpolyh] $SUB=6 $X=58170 $Y=1660 $dt=0
R76 89 95 37927.7 L=1e-05 W=5e-07 $[rnpolyh] $SUB=6 $X=58920 $Y=1660 $dt=0
R77 90 95 37927.7 L=1e-05 W=5e-07 $[rnpolyh] $SUB=6 $X=59670 $Y=1660 $dt=0
R78 90 96 37927.7 L=1e-05 W=5e-07 $[rnpolyh] $SUB=6 $X=60420 $Y=1660 $dt=0
R79 91 96 37927.7 L=1e-05 W=5e-07 $[rnpolyh] $SUB=6 $X=61170 $Y=1660 $dt=0
R80 91 97 37927.7 L=1e-05 W=5e-07 $[rnpolyh] $SUB=6 $X=61920 $Y=1660 $dt=0
R81 92 97 37927.7 L=1e-05 W=5e-07 $[rnpolyh] $SUB=6 $X=62670 $Y=1660 $dt=0
R82 92 98 37927.7 L=1e-05 W=5e-07 $[rnpolyh] $SUB=6 $X=63420 $Y=1660 $dt=0
R83 1 98 37927.7 L=1e-05 W=5e-07 $[rnpolyh] $SUB=6 $X=64170 $Y=1660 $dt=0
R84 1 2 37927.7 L=1e-05 W=5e-07 $[rnpolyh] $SUB=6 $X=64920 $Y=1660 $dt=0
R85 3 2 37927.7 L=1e-05 W=5e-07 $[rnpolyh] $SUB=6 $X=65670 $Y=1660 $dt=0
.ends trim_res_bg_sl_fL
