* +++++++++++++++++++++++++++++++++++++++++++++++++++++++++ *
* CDL Netlist:                                              *
*                                                           *
* Cell Name  : trim_res_bg_sl_fL                            *
* Netlisted  : Sun Jun 21 02:01:59 2026                     *
* PVS Version: 24.11-s045 Mon Jan 27 22:18:54 PST 2025      *
* +++++++++++++++++++++++++++++++++++++++++++++++++++++++++ *
*.LDD
*.DEVTMPLT 0 R(rnpolyh) RNPOLYHNW1V2 POLYG3(POS) POLYG3(NEG) NW1V2(SUB)

* +++++++++++++++++++++++++++++++++++++++++++++++++++++++++ *
* Sub cell: rnpolyh_CDNS_782007315130                       *
* +++++++++++++++++++++++++++++++++++++++++++++++++++++++++ *
.subckt rnpolyh_CDNS_782007315130 2 3 4
** N=4 EP=3 FDC=1
R0 3 2 37927.7 L=1e-05 W=5e-07 $[rnpolyh] $SUB=4 $X=0 $Y=0 $dt=0
.ends rnpolyh_CDNS_782007315130

* +++++++++++++++++++++++++++++++++++++++++++++++++++++++++ *
* Sub cell: rnpolyh_CDNS_782007315133                       *
* +++++++++++++++++++++++++++++++++++++++++++++++++++++++++ *
.subckt rnpolyh_CDNS_782007315133 2
** N=2 EP=1 FDC=1
R0 2 2 37927.7 L=1e-05 W=5e-07 $[rnpolyh] $SUB=2 $X=0 $Y=0 $dt=0
.ends rnpolyh_CDNS_782007315133

* +++++++++++++++++++++++++++++++++++++++++++++++++++++++++ *
* Sub cell: trim_res_bg_sl_fL                               *
* +++++++++++++++++++++++++++++++++++++++++++++++++++++++++ *
.subckt trim_res_bg_sl_fL P1 P2 REF S0 S1 S2 S3 S4 S5 S6
+ S7
** N=99 EP=11 FDC=97
X4 S0 3 REF rnpolyh_CDNS_782007315130 $T=66420 1660 0 0 $X=66170 $Y=920
X5 S1 S0 REF rnpolyh_CDNS_782007315130 $T=67670 11660 0 180 $X=66920 $Y=920
X6 S2 S1 REF rnpolyh_CDNS_782007315130 $T=67920 1660 0 0 $X=67670 $Y=920
X7 S3 S2 REF rnpolyh_CDNS_782007315130 $T=68670 11660 1 0 $X=68420 $Y=920
X8 S4 S3 REF rnpolyh_CDNS_782007315130 $T=69420 1660 0 0 $X=69170 $Y=920
X9 S5 S4 REF rnpolyh_CDNS_782007315130 $T=70170 11660 1 0 $X=69920 $Y=920
X10 S6 S5 REF rnpolyh_CDNS_782007315130 $T=70920 1660 0 0 $X=70670 $Y=920
X11 S7 S6 REF rnpolyh_CDNS_782007315130 $T=71670 11660 1 0 $X=71420 $Y=920
X12 P2 S7 REF rnpolyh_CDNS_782007315130 $T=72420 1660 0 0 $X=72170 $Y=920
X13 REF rnpolyh_CDNS_782007315133 $T=1170 1660 0 0 $X=920 $Y=920
X14 REF rnpolyh_CDNS_782007315133 $T=73170 1660 0 0 $X=72920 $Y=920
R0 P1 22 37927.7 L=1e-05 W=5e-07 $[rnpolyh] $SUB=REF $X=1920 $Y=1660 $dt=0
R1 16 22 37927.7 L=1e-05 W=5e-07 $[rnpolyh] $SUB=REF $X=2670 $Y=1660 $dt=0
R2 16 23 37927.7 L=1e-05 W=5e-07 $[rnpolyh] $SUB=REF $X=3420 $Y=1660 $dt=0
R3 17 23 37927.7 L=1e-05 W=5e-07 $[rnpolyh] $SUB=REF $X=4170 $Y=1660 $dt=0
R4 17 24 37927.7 L=1e-05 W=5e-07 $[rnpolyh] $SUB=REF $X=4920 $Y=1660 $dt=0
R5 18 24 37927.7 L=1e-05 W=5e-07 $[rnpolyh] $SUB=REF $X=5670 $Y=1660 $dt=0
R6 18 25 37927.7 L=1e-05 W=5e-07 $[rnpolyh] $SUB=REF $X=6420 $Y=1660 $dt=0
R7 19 25 37927.7 L=1e-05 W=5e-07 $[rnpolyh] $SUB=REF $X=7170 $Y=1660 $dt=0
R8 19 26 37927.7 L=1e-05 W=5e-07 $[rnpolyh] $SUB=REF $X=7920 $Y=1660 $dt=0
R9 20 26 37927.7 L=1e-05 W=5e-07 $[rnpolyh] $SUB=REF $X=8670 $Y=1660 $dt=0
R10 20 27 37927.7 L=1e-05 W=5e-07 $[rnpolyh] $SUB=REF $X=9420 $Y=1660 $dt=0
R11 21 27 37927.7 L=1e-05 W=5e-07 $[rnpolyh] $SUB=REF $X=10170 $Y=1660 $dt=0
R12 21 34 37927.7 L=1e-05 W=5e-07 $[rnpolyh] $SUB=REF $X=10920 $Y=1660 $dt=0
R13 28 34 37927.7 L=1e-05 W=5e-07 $[rnpolyh] $SUB=REF $X=11670 $Y=1660 $dt=0
R14 28 35 37927.7 L=1e-05 W=5e-07 $[rnpolyh] $SUB=REF $X=12420 $Y=1660 $dt=0
R15 29 35 37927.7 L=1e-05 W=5e-07 $[rnpolyh] $SUB=REF $X=13170 $Y=1660 $dt=0
R16 29 36 37927.7 L=1e-05 W=5e-07 $[rnpolyh] $SUB=REF $X=13920 $Y=1660 $dt=0
R17 30 36 37927.7 L=1e-05 W=5e-07 $[rnpolyh] $SUB=REF $X=14670 $Y=1660 $dt=0
R18 30 37 37927.7 L=1e-05 W=5e-07 $[rnpolyh] $SUB=REF $X=15420 $Y=1660 $dt=0
R19 31 37 37927.7 L=1e-05 W=5e-07 $[rnpolyh] $SUB=REF $X=16170 $Y=1660 $dt=0
R20 31 38 37927.7 L=1e-05 W=5e-07 $[rnpolyh] $SUB=REF $X=16920 $Y=1660 $dt=0
R21 32 38 37927.7 L=1e-05 W=5e-07 $[rnpolyh] $SUB=REF $X=17670 $Y=1660 $dt=0
R22 32 39 37927.7 L=1e-05 W=5e-07 $[rnpolyh] $SUB=REF $X=18420 $Y=1660 $dt=0
R23 33 39 37927.7 L=1e-05 W=5e-07 $[rnpolyh] $SUB=REF $X=19170 $Y=1660 $dt=0
R24 33 46 37927.7 L=1e-05 W=5e-07 $[rnpolyh] $SUB=REF $X=19920 $Y=1660 $dt=0
R25 40 46 37927.7 L=1e-05 W=5e-07 $[rnpolyh] $SUB=REF $X=20670 $Y=1660 $dt=0
R26 40 47 37927.7 L=1e-05 W=5e-07 $[rnpolyh] $SUB=REF $X=21420 $Y=1660 $dt=0
R27 41 47 37927.7 L=1e-05 W=5e-07 $[rnpolyh] $SUB=REF $X=22170 $Y=1660 $dt=0
R28 41 48 37927.7 L=1e-05 W=5e-07 $[rnpolyh] $SUB=REF $X=22920 $Y=1660 $dt=0
R29 42 48 37927.7 L=1e-05 W=5e-07 $[rnpolyh] $SUB=REF $X=23670 $Y=1660 $dt=0
R30 42 49 37927.7 L=1e-05 W=5e-07 $[rnpolyh] $SUB=REF $X=24420 $Y=1660 $dt=0
R31 43 49 37927.7 L=1e-05 W=5e-07 $[rnpolyh] $SUB=REF $X=25170 $Y=1660 $dt=0
R32 43 50 37927.7 L=1e-05 W=5e-07 $[rnpolyh] $SUB=REF $X=25920 $Y=1660 $dt=0
R33 44 50 37927.7 L=1e-05 W=5e-07 $[rnpolyh] $SUB=REF $X=26670 $Y=1660 $dt=0
R34 44 51 37927.7 L=1e-05 W=5e-07 $[rnpolyh] $SUB=REF $X=27420 $Y=1660 $dt=0
R35 45 51 37927.7 L=1e-05 W=5e-07 $[rnpolyh] $SUB=REF $X=28170 $Y=1660 $dt=0
R36 45 58 37927.7 L=1e-05 W=5e-07 $[rnpolyh] $SUB=REF $X=28920 $Y=1660 $dt=0
R37 52 58 37927.7 L=1e-05 W=5e-07 $[rnpolyh] $SUB=REF $X=29670 $Y=1660 $dt=0
R38 52 59 37927.7 L=1e-05 W=5e-07 $[rnpolyh] $SUB=REF $X=30420 $Y=1660 $dt=0
R39 53 59 37927.7 L=1e-05 W=5e-07 $[rnpolyh] $SUB=REF $X=31170 $Y=1660 $dt=0
R40 53 60 37927.7 L=1e-05 W=5e-07 $[rnpolyh] $SUB=REF $X=31920 $Y=1660 $dt=0
R41 54 60 37927.7 L=1e-05 W=5e-07 $[rnpolyh] $SUB=REF $X=32670 $Y=1660 $dt=0
R42 54 61 37927.7 L=1e-05 W=5e-07 $[rnpolyh] $SUB=REF $X=33420 $Y=1660 $dt=0
R43 55 61 37927.7 L=1e-05 W=5e-07 $[rnpolyh] $SUB=REF $X=34170 $Y=1660 $dt=0
R44 55 62 37927.7 L=1e-05 W=5e-07 $[rnpolyh] $SUB=REF $X=34920 $Y=1660 $dt=0
R45 56 62 37927.7 L=1e-05 W=5e-07 $[rnpolyh] $SUB=REF $X=35670 $Y=1660 $dt=0
R46 56 63 37927.7 L=1e-05 W=5e-07 $[rnpolyh] $SUB=REF $X=36420 $Y=1660 $dt=0
R47 57 63 37927.7 L=1e-05 W=5e-07 $[rnpolyh] $SUB=REF $X=37170 $Y=1660 $dt=0
R48 57 70 37927.7 L=1e-05 W=5e-07 $[rnpolyh] $SUB=REF $X=37920 $Y=1660 $dt=0
R49 64 70 37927.7 L=1e-05 W=5e-07 $[rnpolyh] $SUB=REF $X=38670 $Y=1660 $dt=0
R50 64 71 37927.7 L=1e-05 W=5e-07 $[rnpolyh] $SUB=REF $X=39420 $Y=1660 $dt=0
R51 65 71 37927.7 L=1e-05 W=5e-07 $[rnpolyh] $SUB=REF $X=40170 $Y=1660 $dt=0
R52 65 72 37927.7 L=1e-05 W=5e-07 $[rnpolyh] $SUB=REF $X=40920 $Y=1660 $dt=0
R53 66 72 37927.7 L=1e-05 W=5e-07 $[rnpolyh] $SUB=REF $X=41670 $Y=1660 $dt=0
R54 66 73 37927.7 L=1e-05 W=5e-07 $[rnpolyh] $SUB=REF $X=42420 $Y=1660 $dt=0
R55 67 73 37927.7 L=1e-05 W=5e-07 $[rnpolyh] $SUB=REF $X=43170 $Y=1660 $dt=0
R56 67 74 37927.7 L=1e-05 W=5e-07 $[rnpolyh] $SUB=REF $X=43920 $Y=1660 $dt=0
R57 68 74 37927.7 L=1e-05 W=5e-07 $[rnpolyh] $SUB=REF $X=44670 $Y=1660 $dt=0
R58 68 75 37927.7 L=1e-05 W=5e-07 $[rnpolyh] $SUB=REF $X=45420 $Y=1660 $dt=0
R59 69 75 37927.7 L=1e-05 W=5e-07 $[rnpolyh] $SUB=REF $X=46170 $Y=1660 $dt=0
R60 69 82 37927.7 L=1e-05 W=5e-07 $[rnpolyh] $SUB=REF $X=46920 $Y=1660 $dt=0
R61 76 82 37927.7 L=1e-05 W=5e-07 $[rnpolyh] $SUB=REF $X=47670 $Y=1660 $dt=0
R62 76 83 37927.7 L=1e-05 W=5e-07 $[rnpolyh] $SUB=REF $X=48420 $Y=1660 $dt=0
R63 77 83 37927.7 L=1e-05 W=5e-07 $[rnpolyh] $SUB=REF $X=49170 $Y=1660 $dt=0
R64 77 84 37927.7 L=1e-05 W=5e-07 $[rnpolyh] $SUB=REF $X=49920 $Y=1660 $dt=0
R65 78 84 37927.7 L=1e-05 W=5e-07 $[rnpolyh] $SUB=REF $X=50670 $Y=1660 $dt=0
R66 78 85 37927.7 L=1e-05 W=5e-07 $[rnpolyh] $SUB=REF $X=51420 $Y=1660 $dt=0
R67 79 85 37927.7 L=1e-05 W=5e-07 $[rnpolyh] $SUB=REF $X=52170 $Y=1660 $dt=0
R68 79 86 37927.7 L=1e-05 W=5e-07 $[rnpolyh] $SUB=REF $X=52920 $Y=1660 $dt=0
R69 80 86 37927.7 L=1e-05 W=5e-07 $[rnpolyh] $SUB=REF $X=53670 $Y=1660 $dt=0
R70 80 87 37927.7 L=1e-05 W=5e-07 $[rnpolyh] $SUB=REF $X=54420 $Y=1660 $dt=0
R71 81 87 37927.7 L=1e-05 W=5e-07 $[rnpolyh] $SUB=REF $X=55170 $Y=1660 $dt=0
R72 81 93 37927.7 L=1e-05 W=5e-07 $[rnpolyh] $SUB=REF $X=55920 $Y=1660 $dt=0
R73 88 93 37927.7 L=1e-05 W=5e-07 $[rnpolyh] $SUB=REF $X=56670 $Y=1660 $dt=0
R74 88 94 37927.7 L=1e-05 W=5e-07 $[rnpolyh] $SUB=REF $X=57420 $Y=1660 $dt=0
R75 89 94 37927.7 L=1e-05 W=5e-07 $[rnpolyh] $SUB=REF $X=58170 $Y=1660 $dt=0
R76 89 95 37927.7 L=1e-05 W=5e-07 $[rnpolyh] $SUB=REF $X=58920 $Y=1660 $dt=0
R77 90 95 37927.7 L=1e-05 W=5e-07 $[rnpolyh] $SUB=REF $X=59670 $Y=1660 $dt=0
R78 90 96 37927.7 L=1e-05 W=5e-07 $[rnpolyh] $SUB=REF $X=60420 $Y=1660 $dt=0
R79 91 96 37927.7 L=1e-05 W=5e-07 $[rnpolyh] $SUB=REF $X=61170 $Y=1660 $dt=0
R80 91 97 37927.7 L=1e-05 W=5e-07 $[rnpolyh] $SUB=REF $X=61920 $Y=1660 $dt=0
R81 92 97 37927.7 L=1e-05 W=5e-07 $[rnpolyh] $SUB=REF $X=62670 $Y=1660 $dt=0
R82 92 98 37927.7 L=1e-05 W=5e-07 $[rnpolyh] $SUB=REF $X=63420 $Y=1660 $dt=0
R83 1 98 37927.7 L=1e-05 W=5e-07 $[rnpolyh] $SUB=REF $X=64170 $Y=1660 $dt=0
R84 1 2 37927.7 L=1e-05 W=5e-07 $[rnpolyh] $SUB=REF $X=64920 $Y=1660 $dt=0
R85 3 2 37927.7 L=1e-05 W=5e-07 $[rnpolyh] $SUB=REF $X=65670 $Y=1660 $dt=0
.ends trim_res_bg_sl_fL
