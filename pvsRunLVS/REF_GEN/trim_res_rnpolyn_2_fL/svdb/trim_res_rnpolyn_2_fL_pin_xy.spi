* +++++++++++++++++++++++++++++++++++++++++++++++++++++++++ *
* CDL Netlist:                                              *
*                                                           *
* Cell Name  : trim_res_rnpolyn_2_fL                        *
* Netlisted  : Thu Jul  2 14:05:19 2026                     *
* PVS Version: 24.11-s045 Mon Jan 27 22:18:54 PST 2025      *
* +++++++++++++++++++++++++++++++++++++++++++++++++++++++++ *
*.LDD
*.DEVTMPLT 0 R(rnpolym) RNPOLYMNW1V2 POLYG3(POS) POLYG3(NEG) NW1V2(SUB)

* +++++++++++++++++++++++++++++++++++++++++++++++++++++++++ *
* Sub cell: Contact_CDNS_783001115461                       *
* +++++++++++++++++++++++++++++++++++++++++++++++++++++++++ *
.subckt Contact_CDNS_783001115461 1
** N=1 EP=1 FDC=0
.ends Contact_CDNS_783001115461

* +++++++++++++++++++++++++++++++++++++++++++++++++++++++++ *
* Sub cell: rnpolym_CDNS_783001115462                       *
* +++++++++++++++++++++++++++++++++++++++++++++++++++++++++ *
.subckt rnpolym_CDNS_783001115462 1 2 3 4
** N=4 EP=4 FDC=1
X0 3 Contact_CDNS_783001115461 $T=-30 -520 0 0 $X=-50 $Y=-540
X1 2 Contact_CDNS_783001115461 $T=-30 35260 0 0 $X=-50 $Y=35240
R0 3 2 16727.1 L=3.5e-05 W=5e-07 $[rnpolym] $SUB=4 $X=0 $Y=0 $dt=0
.ends rnpolym_CDNS_783001115462

* +++++++++++++++++++++++++++++++++++++++++++++++++++++++++ *
* Sub cell: trim_res_rnpolyn_2_fL                           *
* +++++++++++++++++++++++++++++++++++++++++++++++++++++++++ *
.subckt trim_res_rnpolyn_2_fL 5 1 2
** N=6 EP=3 FDC=14
X0 1 Contact_CDNS_783001115461 $T=225 225 0 0 $X=205 $Y=205
X1 2 Contact_CDNS_783001115461 $T=225 36005 0 0 $X=205 $Y=35985
X2 1 Contact_CDNS_783001115461 $T=975 225 0 0 $X=955 $Y=205
X3 2 Contact_CDNS_783001115461 $T=975 36005 0 0 $X=955 $Y=35985
X4 1 Contact_CDNS_783001115461 $T=1725 225 0 0 $X=1705 $Y=205
X5 2 Contact_CDNS_783001115461 $T=1725 36005 0 0 $X=1705 $Y=35985
X6 1 Contact_CDNS_783001115461 $T=2475 225 0 0 $X=2455 $Y=205
X7 2 Contact_CDNS_783001115461 $T=2475 36005 0 0 $X=2455 $Y=35985
X8 1 Contact_CDNS_783001115461 $T=3225 225 0 0 $X=3205 $Y=205
X9 2 Contact_CDNS_783001115461 $T=3225 36005 0 0 $X=3205 $Y=35985
X10 1 Contact_CDNS_783001115461 $T=3975 225 0 0 $X=3955 $Y=205
X11 2 Contact_CDNS_783001115461 $T=3975 36005 0 0 $X=3955 $Y=35985
X12 1 Contact_CDNS_783001115461 $T=4725 225 0 0 $X=4705 $Y=205
X13 2 Contact_CDNS_783001115461 $T=4725 36005 0 0 $X=4705 $Y=35985
X14 1 Contact_CDNS_783001115461 $T=5475 225 0 0 $X=5455 $Y=205
X15 2 Contact_CDNS_783001115461 $T=5475 36005 0 0 $X=5455 $Y=35985
X16 1 Contact_CDNS_783001115461 $T=6225 225 0 0 $X=6205 $Y=205
X17 2 Contact_CDNS_783001115461 $T=6225 36005 0 0 $X=6205 $Y=35985
X18 1 Contact_CDNS_783001115461 $T=6975 225 0 0 $X=6955 $Y=205
X19 2 Contact_CDNS_783001115461 $T=6975 36005 0 0 $X=6955 $Y=35985
X20 1 Contact_CDNS_783001115461 $T=7725 225 0 0 $X=7705 $Y=205
X21 2 Contact_CDNS_783001115461 $T=7725 36005 0 0 $X=7705 $Y=35985
X22 1 Contact_CDNS_783001115461 $T=8475 225 0 0 $X=8455 $Y=205
X23 2 Contact_CDNS_783001115461 $T=8475 36005 0 0 $X=8455 $Y=35985
X24 3 4 1 5 rnpolym_CDNS_783001115462 $T=9255 745 0 0 $X=9005 $Y=5
X25 3 2 4 5 rnpolym_CDNS_783001115462 $T=10005 35745 1 0 $X=9755 $Y=5
R0 1 2 16727.1 L=3.5e-05 W=5e-07 $[rnpolym] $SUB=5 $X=255 $Y=745 $dt=0
R1 1 2 16727.1 L=3.5e-05 W=5e-07 $[rnpolym] $SUB=5 $X=1005 $Y=745 $dt=0
R2 1 2 16727.1 L=3.5e-05 W=5e-07 $[rnpolym] $SUB=5 $X=1755 $Y=745 $dt=0
R3 1 2 16727.1 L=3.5e-05 W=5e-07 $[rnpolym] $SUB=5 $X=2505 $Y=745 $dt=0
R4 1 2 16727.1 L=3.5e-05 W=5e-07 $[rnpolym] $SUB=5 $X=3255 $Y=745 $dt=0
R5 1 2 16727.1 L=3.5e-05 W=5e-07 $[rnpolym] $SUB=5 $X=4005 $Y=745 $dt=0
R6 1 2 16727.1 L=3.5e-05 W=5e-07 $[rnpolym] $SUB=5 $X=4755 $Y=745 $dt=0
R7 1 2 16727.1 L=3.5e-05 W=5e-07 $[rnpolym] $SUB=5 $X=5505 $Y=745 $dt=0
R8 1 2 16727.1 L=3.5e-05 W=5e-07 $[rnpolym] $SUB=5 $X=6255 $Y=745 $dt=0
R9 1 2 16727.1 L=3.5e-05 W=5e-07 $[rnpolym] $SUB=5 $X=7005 $Y=745 $dt=0
R10 1 2 16727.1 L=3.5e-05 W=5e-07 $[rnpolym] $SUB=5 $X=7755 $Y=745 $dt=0
R11 1 2 16727.1 L=3.5e-05 W=5e-07 $[rnpolym] $SUB=5 $X=8505 $Y=745 $dt=0
.ends trim_res_rnpolyn_2_fL
