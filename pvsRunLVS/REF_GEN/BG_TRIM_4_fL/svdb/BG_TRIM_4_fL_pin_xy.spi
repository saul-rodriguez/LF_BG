* +++++++++++++++++++++++++++++++++++++++++++++++++++++++++ *
* CDL Netlist:                                              *
*                                                           *
* Cell Name  : BG_TRIM_4_fL                                 *
* Netlisted  : Wed Jun 24 13:13:06 2026                     *
* PVS Version: 24.11-s045 Mon Jan 27 22:18:54 PST 2025      *
* +++++++++++++++++++++++++++++++++++++++++++++++++++++++++ *
*.LDD
*.DEVTMPLT 0 C(cmims2) CMIMS2 TOPMIMS2(POS) METAL5a(NEG)
*.DEVTMPLT 1 MN(nmos1v2hvt) NMOS1V2HVT NDIFF(D) NGATE(G) NDIFF(S) PW1V2(B)
*.DEVTMPLT 2 MP(pmos1v2hvt) PMOS1V2HVT PDIFF(D) PGATE(G) PDIFF(S) NW1V2(B)
*.DEVTMPLT 3 R(rnpolyh) RNPOLYHNW1V2 POLYG3(POS) POLYG3(NEG) NW1V2(SUB)
*.DEVTMPLT 4 Q(pnp5ux5u) PNP5UX5U PW1V2(C) PNPBASE(B) PNPEMIT5UX5U(E)

* +++++++++++++++++++++++++++++++++++++++++++++++++++++++++ *
* Sub cell: M2_M3_CDNS_782306781570                         *
* +++++++++++++++++++++++++++++++++++++++++++++++++++++++++ *
.subckt M2_M3_CDNS_782306781570 1
** N=1 EP=1 FDC=0
.ends M2_M3_CDNS_782306781570

* +++++++++++++++++++++++++++++++++++++++++++++++++++++++++ *
* Sub cell: M1_M2_CDNS_782306781571                         *
* +++++++++++++++++++++++++++++++++++++++++++++++++++++++++ *
.subckt M1_M2_CDNS_782306781571 1
** N=1 EP=1 FDC=0
.ends M1_M2_CDNS_782306781571

* +++++++++++++++++++++++++++++++++++++++++++++++++++++++++ *
* Sub cell: M1_M2_CDNS_782306781572                         *
* +++++++++++++++++++++++++++++++++++++++++++++++++++++++++ *
.subckt M1_M2_CDNS_782306781572 1
** N=1 EP=1 FDC=0
.ends M1_M2_CDNS_782306781572

* +++++++++++++++++++++++++++++++++++++++++++++++++++++++++ *
* Sub cell: M1_M2_CDNS_782306781573                         *
* +++++++++++++++++++++++++++++++++++++++++++++++++++++++++ *
.subckt M1_M2_CDNS_782306781573 1
** N=1 EP=1 FDC=0
.ends M1_M2_CDNS_782306781573

* +++++++++++++++++++++++++++++++++++++++++++++++++++++++++ *
* Sub cell: M1_M2_CDNS_782306781574                         *
* +++++++++++++++++++++++++++++++++++++++++++++++++++++++++ *
.subckt M1_M2_CDNS_782306781574 1
** N=1 EP=1 FDC=0
.ends M1_M2_CDNS_782306781574

* +++++++++++++++++++++++++++++++++++++++++++++++++++++++++ *
* Sub cell: M1_M2_CDNS_782306781575                         *
* +++++++++++++++++++++++++++++++++++++++++++++++++++++++++ *
.subckt M1_M2_CDNS_782306781575 1
** N=1 EP=1 FDC=0
.ends M1_M2_CDNS_782306781575

* +++++++++++++++++++++++++++++++++++++++++++++++++++++++++ *
* Sub cell: M2_M3_CDNS_782306781576                         *
* +++++++++++++++++++++++++++++++++++++++++++++++++++++++++ *
.subckt M2_M3_CDNS_782306781576 1
** N=1 EP=1 FDC=0
.ends M2_M3_CDNS_782306781576

* +++++++++++++++++++++++++++++++++++++++++++++++++++++++++ *
* Sub cell: PG_M1_CDNS_782306781578                         *
* +++++++++++++++++++++++++++++++++++++++++++++++++++++++++ *
.subckt PG_M1_CDNS_782306781578 1
** N=1 EP=1 FDC=0
.ends PG_M1_CDNS_782306781578

* +++++++++++++++++++++++++++++++++++++++++++++++++++++++++ *
* Sub cell: M1_M2_CDNS_782306781579                         *
* +++++++++++++++++++++++++++++++++++++++++++++++++++++++++ *
.subckt M1_M2_CDNS_782306781579 1
** N=1 EP=1 FDC=0
.ends M1_M2_CDNS_782306781579

* +++++++++++++++++++++++++++++++++++++++++++++++++++++++++ *
* Sub cell: M1_M2_CDNS_7823067815710                        *
* +++++++++++++++++++++++++++++++++++++++++++++++++++++++++ *
.subckt M1_M2_CDNS_7823067815710 1
** N=1 EP=1 FDC=0
.ends M1_M2_CDNS_7823067815710

* +++++++++++++++++++++++++++++++++++++++++++++++++++++++++ *
* Sub cell: M1_M2_CDNS_7823067815711                        *
* +++++++++++++++++++++++++++++++++++++++++++++++++++++++++ *
.subckt M1_M2_CDNS_7823067815711 1
** N=1 EP=1 FDC=0
.ends M1_M2_CDNS_7823067815711

* +++++++++++++++++++++++++++++++++++++++++++++++++++++++++ *
* Sub cell: PG_M1_CDNS_7823067815712                        *
* +++++++++++++++++++++++++++++++++++++++++++++++++++++++++ *
.subckt PG_M1_CDNS_7823067815712 1
** N=1 EP=1 FDC=0
.ends PG_M1_CDNS_7823067815712

* +++++++++++++++++++++++++++++++++++++++++++++++++++++++++ *
* Sub cell: M1_M2_CDNS_7823067815716                        *
* +++++++++++++++++++++++++++++++++++++++++++++++++++++++++ *
.subckt M1_M2_CDNS_7823067815716 1
** N=1 EP=1 FDC=0
.ends M1_M2_CDNS_7823067815716

* +++++++++++++++++++++++++++++++++++++++++++++++++++++++++ *
* Sub cell: PG_M1_CDNS_7823067815717                        *
* +++++++++++++++++++++++++++++++++++++++++++++++++++++++++ *
.subckt PG_M1_CDNS_7823067815717 1
** N=1 EP=1 FDC=0
.ends PG_M1_CDNS_7823067815717

* +++++++++++++++++++++++++++++++++++++++++++++++++++++++++ *
* Sub cell: M2_M3_CDNS_7823067815718                        *
* +++++++++++++++++++++++++++++++++++++++++++++++++++++++++ *
.subckt M2_M3_CDNS_7823067815718 1
** N=1 EP=1 FDC=0
.ends M2_M3_CDNS_7823067815718

* +++++++++++++++++++++++++++++++++++++++++++++++++++++++++ *
* Sub cell: M2_M3_CDNS_7823067815721                        *
* +++++++++++++++++++++++++++++++++++++++++++++++++++++++++ *
.subckt M2_M3_CDNS_7823067815721 1
** N=1 EP=1 FDC=0
.ends M2_M3_CDNS_7823067815721

* +++++++++++++++++++++++++++++++++++++++++++++++++++++++++ *
* Sub cell: M1_M2_CDNS_7823067815722                        *
* +++++++++++++++++++++++++++++++++++++++++++++++++++++++++ *
.subckt M1_M2_CDNS_7823067815722 1
** N=1 EP=1 FDC=0
.ends M1_M2_CDNS_7823067815722

* +++++++++++++++++++++++++++++++++++++++++++++++++++++++++ *
* Sub cell: M1_M2_CDNS_7823067815723                        *
* +++++++++++++++++++++++++++++++++++++++++++++++++++++++++ *
.subckt M1_M2_CDNS_7823067815723 1
** N=1 EP=1 FDC=0
.ends M1_M2_CDNS_7823067815723

* +++++++++++++++++++++++++++++++++++++++++++++++++++++++++ *
* Sub cell: M1_M2_CDNS_7823067815724                        *
* +++++++++++++++++++++++++++++++++++++++++++++++++++++++++ *
.subckt M1_M2_CDNS_7823067815724 1
** N=1 EP=1 FDC=0
.ends M1_M2_CDNS_7823067815724

* +++++++++++++++++++++++++++++++++++++++++++++++++++++++++ *
* Sub cell: M1_M2_CDNS_7823067815725                        *
* +++++++++++++++++++++++++++++++++++++++++++++++++++++++++ *
.subckt M1_M2_CDNS_7823067815725 1
** N=1 EP=1 FDC=0
.ends M1_M2_CDNS_7823067815725

* +++++++++++++++++++++++++++++++++++++++++++++++++++++++++ *
* Sub cell: M2_M3_CDNS_7823067815727                        *
* +++++++++++++++++++++++++++++++++++++++++++++++++++++++++ *
.subckt M2_M3_CDNS_7823067815727 1
** N=1 EP=1 FDC=0
.ends M2_M3_CDNS_7823067815727

* +++++++++++++++++++++++++++++++++++++++++++++++++++++++++ *
* Sub cell: M2_M3_CDNS_7823067815728                        *
* +++++++++++++++++++++++++++++++++++++++++++++++++++++++++ *
.subckt M2_M3_CDNS_7823067815728 1
** N=1 EP=1 FDC=0
.ends M2_M3_CDNS_7823067815728

* +++++++++++++++++++++++++++++++++++++++++++++++++++++++++ *
* Sub cell: M2_M3_CDNS_7823067815732                        *
* +++++++++++++++++++++++++++++++++++++++++++++++++++++++++ *
.subckt M2_M3_CDNS_7823067815732 1
** N=1 EP=1 FDC=0
.ends M2_M3_CDNS_7823067815732

* +++++++++++++++++++++++++++++++++++++++++++++++++++++++++ *
* Sub cell: M1_M2_CDNS_7823067815734                        *
* +++++++++++++++++++++++++++++++++++++++++++++++++++++++++ *
.subckt M1_M2_CDNS_7823067815734 1
** N=1 EP=1 FDC=0
.ends M1_M2_CDNS_7823067815734

* +++++++++++++++++++++++++++++++++++++++++++++++++++++++++ *
* Sub cell: M2_M3_CDNS_7823067815735                        *
* +++++++++++++++++++++++++++++++++++++++++++++++++++++++++ *
.subckt M2_M3_CDNS_7823067815735 1
** N=1 EP=1 FDC=0
.ends M2_M3_CDNS_7823067815735

* +++++++++++++++++++++++++++++++++++++++++++++++++++++++++ *
* Sub cell: M1_M2_CDNS_7823067815737                        *
* +++++++++++++++++++++++++++++++++++++++++++++++++++++++++ *
.subckt M1_M2_CDNS_7823067815737 1
** N=1 EP=1 FDC=0
.ends M1_M2_CDNS_7823067815737

* +++++++++++++++++++++++++++++++++++++++++++++++++++++++++ *
* Sub cell: cmims_CDNS_782306781570                         *
* +++++++++++++++++++++++++++++++++++++++++++++++++++++++++ *
.subckt cmims_CDNS_782306781570 1 2
** N=2 EP=2 FDC=1
C0 2 1 6.3478e-13 L=7e-05 W=9e-06 m=1 $A=6.3e-10 $P=0.000158 $[cmims2] $X=0 $Y=0 $dt=0
.ends cmims_CDNS_782306781570

* +++++++++++++++++++++++++++++++++++++++++++++++++++++++++ *
* Sub cell: Contact_CDNS_782306781572                       *
* +++++++++++++++++++++++++++++++++++++++++++++++++++++++++ *
.subckt Contact_CDNS_782306781572 1
** N=1 EP=1 FDC=0
.ends Contact_CDNS_782306781572

* +++++++++++++++++++++++++++++++++++++++++++++++++++++++++ *
* Sub cell: Contact_CDNS_782306781573                       *
* +++++++++++++++++++++++++++++++++++++++++++++++++++++++++ *
.subckt Contact_CDNS_782306781573 1
** N=1 EP=1 FDC=0
.ends Contact_CDNS_782306781573

* +++++++++++++++++++++++++++++++++++++++++++++++++++++++++ *
* Sub cell: AbutContact_CDNS_782306781574                   *
* +++++++++++++++++++++++++++++++++++++++++++++++++++++++++ *
.subckt AbutContact_CDNS_782306781574 1 2
** N=2 EP=2 FDC=0
.ends AbutContact_CDNS_782306781574

* +++++++++++++++++++++++++++++++++++++++++++++++++++++++++ *
* Sub cell: pmos1v2hvt_4_CDNS_782306781571                  *
* +++++++++++++++++++++++++++++++++++++++++++++++++++++++++ *
.subckt pmos1v2hvt_4_CDNS_782306781571 1 2
** N=2 EP=2 FDC=1
X0 1 Contact_CDNS_782306781572 $T=-245 130 0 0 $X=-245 $Y=0
X1 1 Contact_CDNS_782306781572 $T=10095 130 0 0 $X=10095 $Y=0
X2 1 Contact_CDNS_782306781573 $T=2620 1100 0 0 $X=2500 $Y=1100
X3 1 2 AbutContact_CDNS_782306781574 $T=-330 -560 0 0 $X=-520 $Y=-620
M0 1 1 1 1 pmos1v2hvt L=1e-05 W=1e-06 AD=3e-13 AS=3e-13 PD=1.6e-06 PS=1.6e-06 m=1 $X=0 $Y=0 $dt=2
.ends pmos1v2hvt_4_CDNS_782306781571

* +++++++++++++++++++++++++++++++++++++++++++++++++++++++++ *
* Sub cell: Contact_CDNS_782306781576                       *
* +++++++++++++++++++++++++++++++++++++++++++++++++++++++++ *
.subckt Contact_CDNS_782306781576 1
** N=1 EP=1 FDC=0
.ends Contact_CDNS_782306781576

* +++++++++++++++++++++++++++++++++++++++++++++++++++++++++ *
* Sub cell: rnpolyh_CDNS_782306781575                       *
* +++++++++++++++++++++++++++++++++++++++++++++++++++++++++ *
.subckt rnpolyh_CDNS_782306781575 1 2
** N=2 EP=2 FDC=1
X0 1 Contact_CDNS_782306781576 $T=-30 -520 0 0 $X=-50 $Y=-540
X1 1 Contact_CDNS_782306781576 $T=-30 10260 0 0 $X=-50 $Y=10240
R0 1 1 37927.7 L=1e-05 W=5e-07 $[rnpolyh] $SUB=1 $X=0 $Y=0 $dt=3
.ends rnpolyh_CDNS_782306781575

* +++++++++++++++++++++++++++++++++++++++++++++++++++++++++ *
* Sub cell: Contact_CDNS_782306781578                       *
* +++++++++++++++++++++++++++++++++++++++++++++++++++++++++ *
.subckt Contact_CDNS_782306781578 1 2
** N=2 EP=2 FDC=0
.ends Contact_CDNS_782306781578

* +++++++++++++++++++++++++++++++++++++++++++++++++++++++++ *
* Sub cell: Contact_CDNS_782306781579                       *
* +++++++++++++++++++++++++++++++++++++++++++++++++++++++++ *
.subckt Contact_CDNS_782306781579 1
** N=1 EP=1 FDC=0
.ends Contact_CDNS_782306781579

* +++++++++++++++++++++++++++++++++++++++++++++++++++++++++ *
* Sub cell: nmos1v2hvt_4_CDNS_782306781577                  *
* +++++++++++++++++++++++++++++++++++++++++++++++++++++++++ *
.subckt nmos1v2hvt_4_CDNS_782306781577 1 2 3 4
** N=4 EP=4 FDC=1
X0 1 4 Contact_CDNS_782306781578 $T=-245 130 0 0 $X=-245 $Y=0
X1 2 4 Contact_CDNS_782306781578 $T=1095 130 0 0 $X=1095 $Y=0
X2 1 Contact_CDNS_782306781579 $T=-275 140 0 0 $X=-275 $Y=0
X3 2 Contact_CDNS_782306781579 $T=1065 140 0 0 $X=1065 $Y=0
M0 2 3 1 4 nmos1v2hvt L=1e-06 W=1e-05 AD=3e-12 AS=3e-12 PD=1.06e-05 PS=1.06e-05 m=1 $X=0 $Y=0 $dt=1
.ends nmos1v2hvt_4_CDNS_782306781577

* +++++++++++++++++++++++++++++++++++++++++++++++++++++++++ *
* Sub cell: mux8_1_fL                                       *
* +++++++++++++++++++++++++++++++++++++++++++++++++++++++++ *
.subckt mux8_1_fL 1 2 3 4 5 6 7 8 9 10
+ 11 12 13 14 15 16 17 18
** N=18 EP=18 FDC=8
X0 1 M1_M2_CDNS_7823067815710 $T=2015 11725 0 0 $X=1735 $Y=11415
X1 2 M1_M2_CDNS_7823067815710 $T=4215 11725 0 0 $X=3935 $Y=11415
X2 3 M1_M2_CDNS_7823067815710 $T=6415 11725 0 0 $X=6135 $Y=11415
X3 5 M1_M2_CDNS_7823067815710 $T=8615 11725 0 0 $X=8335 $Y=11415
X4 6 M1_M2_CDNS_7823067815710 $T=10815 11725 0 0 $X=10535 $Y=11415
X5 7 M1_M2_CDNS_7823067815710 $T=13015 11725 0 0 $X=12735 $Y=11415
X6 8 M1_M2_CDNS_7823067815710 $T=15215 11725 0 0 $X=14935 $Y=11415
X7 9 M1_M2_CDNS_7823067815710 $T=17415 11725 0 0 $X=17135 $Y=11415
X8 1 M2_M3_CDNS_7823067815728 $T=2015 11725 0 0 $X=1685 $Y=11375
X9 2 M2_M3_CDNS_7823067815728 $T=4215 11725 0 0 $X=3885 $Y=11375
X10 3 M2_M3_CDNS_7823067815728 $T=6415 11725 0 0 $X=6085 $Y=11375
X11 5 M2_M3_CDNS_7823067815728 $T=8615 11725 0 0 $X=8285 $Y=11375
X12 6 M2_M3_CDNS_7823067815728 $T=10815 11725 0 0 $X=10485 $Y=11375
X13 7 M2_M3_CDNS_7823067815728 $T=13015 11725 0 0 $X=12685 $Y=11375
X14 8 M2_M3_CDNS_7823067815728 $T=15215 11725 0 0 $X=14885 $Y=11375
X15 9 M2_M3_CDNS_7823067815728 $T=17415 11725 0 0 $X=17085 $Y=11375
X16 10 11 1 4 nmos1v2hvt_4_CDNS_782306781577 $T=1515 1315 0 0 $X=915 $Y=915
X17 10 12 2 4 nmos1v2hvt_4_CDNS_782306781577 $T=3715 1315 0 0 $X=3115 $Y=915
X18 10 13 3 4 nmos1v2hvt_4_CDNS_782306781577 $T=5915 1315 0 0 $X=5315 $Y=915
X19 10 14 5 4 nmos1v2hvt_4_CDNS_782306781577 $T=8115 1315 0 0 $X=7515 $Y=915
X20 10 15 6 4 nmos1v2hvt_4_CDNS_782306781577 $T=10315 1315 0 0 $X=9715 $Y=915
X21 10 16 7 4 nmos1v2hvt_4_CDNS_782306781577 $T=12515 1315 0 0 $X=11915 $Y=915
X22 10 17 8 4 nmos1v2hvt_4_CDNS_782306781577 $T=14715 1315 0 0 $X=14115 $Y=915
X23 10 18 9 4 nmos1v2hvt_4_CDNS_782306781577 $T=16915 1315 0 0 $X=16315 $Y=915
.ends mux8_1_fL

* +++++++++++++++++++++++++++++++++++++++++++++++++++++++++ *
* Sub cell: MASCO__Y3                                       *
* +++++++++++++++++++++++++++++++++++++++++++++++++++++++++ *
.subckt MASCO__Y3 1 2 3 4 5
** N=5 EP=5 FDC=0
X0 5 Contact_CDNS_782306781576 $T=20 20 0 0 $X=0 $Y=0
X1 4 Contact_CDNS_782306781576 $T=770 20 0 0 $X=750 $Y=0
X2 3 Contact_CDNS_782306781576 $T=1520 20 0 0 $X=1500 $Y=0
X3 2 Contact_CDNS_782306781576 $T=2270 20 0 0 $X=2250 $Y=0
X4 1 Contact_CDNS_782306781576 $T=3020 20 0 0 $X=3000 $Y=0
.ends MASCO__Y3

* +++++++++++++++++++++++++++++++++++++++++++++++++++++++++ *
* Sub cell: rnpolyh_CDNS_7823067815711                      *
* +++++++++++++++++++++++++++++++++++++++++++++++++++++++++ *
.subckt rnpolyh_CDNS_7823067815711 1 2 3
** N=27 EP=3 FDC=25
X0 4 4 5 5 2 MASCO__Y3 $T=-50 -540 0 0 $X=-50 $Y=-540
X1 6 7 7 8 8 MASCO__Y3 $T=-50 10240 0 0 $X=-50 $Y=10240
X2 9 10 10 11 11 MASCO__Y3 $T=3700 -540 0 0 $X=3700 $Y=-540
X3 12 12 13 13 6 MASCO__Y3 $T=3700 10240 0 0 $X=3700 $Y=10240
X4 14 14 15 15 9 MASCO__Y3 $T=7450 -540 0 0 $X=7450 $Y=-540
X5 16 17 17 18 18 MASCO__Y3 $T=7450 10240 0 0 $X=7450 $Y=10240
X6 19 20 20 21 21 MASCO__Y3 $T=11200 -540 0 0 $X=11200 $Y=-540
X7 22 22 23 23 16 MASCO__Y3 $T=11200 10240 0 0 $X=11200 $Y=10240
X8 24 24 25 25 19 MASCO__Y3 $T=14950 -540 0 0 $X=14950 $Y=-540
X9 1 26 26 27 27 MASCO__Y3 $T=14950 10240 0 0 $X=14950 $Y=10240
R0 2 8 37927.7 L=1e-05 W=5e-07 $[rnpolyh] $SUB=3 $X=0 $Y=0 $dt=3
R1 5 8 37927.7 L=1e-05 W=5e-07 $[rnpolyh] $SUB=3 $X=750 $Y=0 $dt=3
R2 5 7 37927.7 L=1e-05 W=5e-07 $[rnpolyh] $SUB=3 $X=1500 $Y=0 $dt=3
R3 4 7 37927.7 L=1e-05 W=5e-07 $[rnpolyh] $SUB=3 $X=2250 $Y=0 $dt=3
R4 4 6 37927.7 L=1e-05 W=5e-07 $[rnpolyh] $SUB=3 $X=3000 $Y=0 $dt=3
R5 11 6 37927.7 L=1e-05 W=5e-07 $[rnpolyh] $SUB=3 $X=3750 $Y=0 $dt=3
R6 11 13 37927.7 L=1e-05 W=5e-07 $[rnpolyh] $SUB=3 $X=4500 $Y=0 $dt=3
R7 10 13 37927.7 L=1e-05 W=5e-07 $[rnpolyh] $SUB=3 $X=5250 $Y=0 $dt=3
R8 10 12 37927.7 L=1e-05 W=5e-07 $[rnpolyh] $SUB=3 $X=6000 $Y=0 $dt=3
R9 9 12 37927.7 L=1e-05 W=5e-07 $[rnpolyh] $SUB=3 $X=6750 $Y=0 $dt=3
R10 9 18 37927.7 L=1e-05 W=5e-07 $[rnpolyh] $SUB=3 $X=7500 $Y=0 $dt=3
R11 15 18 37927.7 L=1e-05 W=5e-07 $[rnpolyh] $SUB=3 $X=8250 $Y=0 $dt=3
R12 15 17 37927.7 L=1e-05 W=5e-07 $[rnpolyh] $SUB=3 $X=9000 $Y=0 $dt=3
R13 14 17 37927.7 L=1e-05 W=5e-07 $[rnpolyh] $SUB=3 $X=9750 $Y=0 $dt=3
R14 14 16 37927.7 L=1e-05 W=5e-07 $[rnpolyh] $SUB=3 $X=10500 $Y=0 $dt=3
R15 21 16 37927.7 L=1e-05 W=5e-07 $[rnpolyh] $SUB=3 $X=11250 $Y=0 $dt=3
R16 21 23 37927.7 L=1e-05 W=5e-07 $[rnpolyh] $SUB=3 $X=12000 $Y=0 $dt=3
R17 20 23 37927.7 L=1e-05 W=5e-07 $[rnpolyh] $SUB=3 $X=12750 $Y=0 $dt=3
R18 20 22 37927.7 L=1e-05 W=5e-07 $[rnpolyh] $SUB=3 $X=13500 $Y=0 $dt=3
R19 19 22 37927.7 L=1e-05 W=5e-07 $[rnpolyh] $SUB=3 $X=14250 $Y=0 $dt=3
R20 19 27 37927.7 L=1e-05 W=5e-07 $[rnpolyh] $SUB=3 $X=15000 $Y=0 $dt=3
R21 25 27 37927.7 L=1e-05 W=5e-07 $[rnpolyh] $SUB=3 $X=15750 $Y=0 $dt=3
R22 25 26 37927.7 L=1e-05 W=5e-07 $[rnpolyh] $SUB=3 $X=16500 $Y=0 $dt=3
R23 24 26 37927.7 L=1e-05 W=5e-07 $[rnpolyh] $SUB=3 $X=17250 $Y=0 $dt=3
R24 24 1 37927.7 L=1e-05 W=5e-07 $[rnpolyh] $SUB=3 $X=18000 $Y=0 $dt=3
.ends rnpolyh_CDNS_7823067815711

* +++++++++++++++++++++++++++++++++++++++++++++++++++++++++ *
* Sub cell: Contact_CDNS_7823067815721                      *
* +++++++++++++++++++++++++++++++++++++++++++++++++++++++++ *
.subckt Contact_CDNS_7823067815721 1
** N=1 EP=1 FDC=0
.ends Contact_CDNS_7823067815721

* +++++++++++++++++++++++++++++++++++++++++++++++++++++++++ *
* Sub cell: AbutContact_CDNS_7823067815722                  *
* +++++++++++++++++++++++++++++++++++++++++++++++++++++++++ *
.subckt AbutContact_CDNS_7823067815722 1
** N=1 EP=1 FDC=0
.ends AbutContact_CDNS_7823067815722

* +++++++++++++++++++++++++++++++++++++++++++++++++++++++++ *
* Sub cell: pmos1v2hvt_4_CDNS_7823067815720                 *
* +++++++++++++++++++++++++++++++++++++++++++++++++++++++++ *
.subckt pmos1v2hvt_4_CDNS_7823067815720 1 2 3 4
** N=4 EP=4 FDC=1
X0 1 Contact_CDNS_7823067815721 $T=-245 180 0 0 $X=-245 $Y=55
X1 2 Contact_CDNS_7823067815721 $T=595 180 0 0 $X=595 $Y=55
X2 1 AbutContact_CDNS_7823067815722 $T=-430 -560 0 0 $X=-520 $Y=-620
M0 2 3 1 1 pmos1v2hvt L=5e-07 W=2e-06 AD=6e-13 AS=6e-13 PD=2.6e-06 PS=2.6e-06 m=1 $X=0 $Y=0 $dt=2
.ends pmos1v2hvt_4_CDNS_7823067815720

* +++++++++++++++++++++++++++++++++++++++++++++++++++++++++ *
* Sub cell: Contact_CDNS_7823067815714                      *
* +++++++++++++++++++++++++++++++++++++++++++++++++++++++++ *
.subckt Contact_CDNS_7823067815714 1
** N=1 EP=1 FDC=0
.ends Contact_CDNS_7823067815714

* +++++++++++++++++++++++++++++++++++++++++++++++++++++++++ *
* Sub cell: Contact_CDNS_7823067815727                      *
* +++++++++++++++++++++++++++++++++++++++++++++++++++++++++ *
.subckt Contact_CDNS_7823067815727 1
** N=1 EP=1 FDC=0
.ends Contact_CDNS_7823067815727

* +++++++++++++++++++++++++++++++++++++++++++++++++++++++++ *
* Sub cell: Contact_CDNS_7823067815728                      *
* +++++++++++++++++++++++++++++++++++++++++++++++++++++++++ *
.subckt Contact_CDNS_7823067815728 1
** N=1 EP=1 FDC=0
.ends Contact_CDNS_7823067815728

* +++++++++++++++++++++++++++++++++++++++++++++++++++++++++ *
* Sub cell: nmos1v2hvt_4_CDNS_7823067815726                 *
* +++++++++++++++++++++++++++++++++++++++++++++++++++++++++ *
.subckt nmos1v2hvt_4_CDNS_7823067815726 1 2 3
** N=3 EP=3 FDC=1
X0 2 Contact_CDNS_7823067815714 $T=70 4140 0 0 $X=0 $Y=4140
X1 1 Contact_CDNS_7823067815727 $T=-245 130 0 0 $X=-245 $Y=0
X2 3 Contact_CDNS_7823067815727 $T=4095 130 0 0 $X=4095 $Y=0
X3 1 Contact_CDNS_7823067815728 $T=-275 115 0 0 $X=-275 $Y=0
X4 3 Contact_CDNS_7823067815728 $T=4065 115 0 0 $X=4065 $Y=0
M0 3 2 1 1 nmos1v2hvt L=4e-06 W=4e-06 AD=1.2e-12 AS=1.2e-12 PD=4.6e-06 PS=4.6e-06 m=1 $X=0 $Y=0 $dt=1
.ends nmos1v2hvt_4_CDNS_7823067815726

* +++++++++++++++++++++++++++++++++++++++++++++++++++++++++ *
* Sub cell: nmos1v2hvt_4_CDNS_7823067815734                 *
* +++++++++++++++++++++++++++++++++++++++++++++++++++++++++ *
.subckt nmos1v2hvt_4_CDNS_7823067815734 1 2 3 4
** N=4 EP=4 FDC=1
X0 1 Contact_CDNS_782306781572 $T=-245 130 0 0 $X=-245 $Y=0
X1 3 Contact_CDNS_782306781572 $T=595 130 0 0 $X=595 $Y=0
M0 3 4 1 2 nmos1v2hvt L=5e-07 W=1e-06 AD=3e-13 AS=3e-13 PD=1.6e-06 PS=1.6e-06 m=1 $X=0 $Y=0 $dt=1
.ends nmos1v2hvt_4_CDNS_7823067815734

* +++++++++++++++++++++++++++++++++++++++++++++++++++++++++ *
* Sub cell: M1_M2_CDNS_7823067815753                        *
* +++++++++++++++++++++++++++++++++++++++++++++++++++++++++ *
.subckt M1_M2_CDNS_7823067815753 1
** N=1 EP=1 FDC=0
.ends M1_M2_CDNS_7823067815753

* +++++++++++++++++++++++++++++++++++++++++++++++++++++++++ *
* Sub cell: M2_M3_CDNS_7823067815754                        *
* +++++++++++++++++++++++++++++++++++++++++++++++++++++++++ *
.subckt M2_M3_CDNS_7823067815754 1
** N=1 EP=1 FDC=0
.ends M2_M3_CDNS_7823067815754

* +++++++++++++++++++++++++++++++++++++++++++++++++++++++++ *
* Sub cell: Contact_CDNS_7823067815713                      *
* +++++++++++++++++++++++++++++++++++++++++++++++++++++++++ *
.subckt Contact_CDNS_7823067815713 1
** N=1 EP=1 FDC=0
.ends Contact_CDNS_7823067815713

* +++++++++++++++++++++++++++++++++++++++++++++++++++++++++ *
* Sub cell: Contact_CDNS_7823067815715                      *
* +++++++++++++++++++++++++++++++++++++++++++++++++++++++++ *
.subckt Contact_CDNS_7823067815715 1
** N=1 EP=1 FDC=0
.ends Contact_CDNS_7823067815715

* +++++++++++++++++++++++++++++++++++++++++++++++++++++++++ *
* Sub cell: pmos1v2hvt_4_CDNS_7823067815712                 *
* +++++++++++++++++++++++++++++++++++++++++++++++++++++++++ *
.subckt pmos1v2hvt_4_CDNS_7823067815712 1 2 3 4
** N=4 EP=4 FDC=1
X0 1 Contact_CDNS_7823067815713 $T=-245 180 0 0 $X=-245 $Y=55
X1 3 Contact_CDNS_7823067815713 $T=4095 180 0 0 $X=4095 $Y=55
X2 2 Contact_CDNS_7823067815714 $T=70 8140 0 0 $X=0 $Y=8140
X3 1 Contact_CDNS_7823067815715 $T=-275 15 0 0 $X=-275 $Y=0
X4 3 Contact_CDNS_7823067815715 $T=4065 15 0 0 $X=4065 $Y=0
M0 3 2 1 1 pmos1v2hvt L=4e-06 W=8e-06 AD=2.4e-12 AS=2.4e-12 PD=8.6e-06 PS=8.6e-06 m=1 $X=0 $Y=0 $dt=2
.ends pmos1v2hvt_4_CDNS_7823067815712

* +++++++++++++++++++++++++++++++++++++++++++++++++++++++++ *
* Sub cell: Contact_CDNS_7823067815718                      *
* +++++++++++++++++++++++++++++++++++++++++++++++++++++++++ *
.subckt Contact_CDNS_7823067815718 1
** N=1 EP=1 FDC=0
.ends Contact_CDNS_7823067815718

* +++++++++++++++++++++++++++++++++++++++++++++++++++++++++ *
* Sub cell: nmos1v2hvt_4_CDNS_7823067815717                 *
* +++++++++++++++++++++++++++++++++++++++++++++++++++++++++ *
.subckt nmos1v2hvt_4_CDNS_7823067815717 1 2 3
** N=3 EP=3 FDC=1
X0 2 Contact_CDNS_782306781572 $T=-245 130 0 0 $X=-245 $Y=0
X1 1 Contact_CDNS_782306781572 $T=295 130 0 0 $X=295 $Y=0
X2 3 Contact_CDNS_7823067815718 $T=-30 1150 0 0 $X=-120 $Y=1150
M0 1 3 2 2 nmos1v2hvt L=2e-07 W=1e-06 AD=3e-13 AS=3e-13 PD=1.6e-06 PS=1.6e-06 m=1 $X=0 $Y=0 $dt=1
.ends nmos1v2hvt_4_CDNS_7823067815717

* +++++++++++++++++++++++++++++++++++++++++++++++++++++++++ *
* Sub cell: nmos1v2hvt_4_CDNS_7823067815723                 *
* +++++++++++++++++++++++++++++++++++++++++++++++++++++++++ *
.subckt nmos1v2hvt_4_CDNS_7823067815723 1 2 3
** N=3 EP=3 FDC=1
X0 1 Contact_CDNS_782306781572 $T=-245 130 0 0 $X=-245 $Y=0
X1 2 Contact_CDNS_782306781572 $T=10095 130 0 0 $X=10095 $Y=0
M0 2 2 1 3 nmos1v2hvt L=1e-05 W=1e-06 AD=3e-13 AS=3e-13 PD=1.6e-06 PS=1.6e-06 m=1 $X=0 $Y=0 $dt=1
.ends nmos1v2hvt_4_CDNS_7823067815723

* +++++++++++++++++++++++++++++++++++++++++++++++++++++++++ *
* Sub cell: Contact_CDNS_7823067815731                      *
* +++++++++++++++++++++++++++++++++++++++++++++++++++++++++ *
.subckt Contact_CDNS_7823067815731 1
** N=1 EP=1 FDC=0
.ends Contact_CDNS_7823067815731

* +++++++++++++++++++++++++++++++++++++++++++++++++++++++++ *
* Sub cell: pmos1v2hvt_4_CDNS_7823067815730                 *
* +++++++++++++++++++++++++++++++++++++++++++++++++++++++++ *
.subckt pmos1v2hvt_4_CDNS_7823067815730 1 2 3 4
** N=4 EP=4 FDC=1
X0 1 Contact_CDNS_7823067815721 $T=-245 180 0 0 $X=-245 $Y=55
X1 2 Contact_CDNS_7823067815721 $T=595 180 0 0 $X=595 $Y=55
X2 1 AbutContact_CDNS_7823067815722 $T=-430 -560 0 0 $X=-520 $Y=-620
X3 3 Contact_CDNS_7823067815731 $T=120 2120 0 0 $X=0 $Y=2120
M0 2 3 1 1 pmos1v2hvt L=5e-07 W=2e-06 AD=6e-13 AS=6e-13 PD=2.6e-06 PS=2.6e-06 m=1 $X=0 $Y=0 $dt=2
.ends pmos1v2hvt_4_CDNS_7823067815730

* +++++++++++++++++++++++++++++++++++++++++++++++++++++++++ *
* Sub cell: pmos1v2hvt_4_CDNS_7823067815732                 *
* +++++++++++++++++++++++++++++++++++++++++++++++++++++++++ *
.subckt pmos1v2hvt_4_CDNS_7823067815732 1 2 3 4
** N=4 EP=4 FDC=1
X0 3 Contact_CDNS_7823067815718 $T=-30 2150 0 0 $X=-120 $Y=2150
X1 1 Contact_CDNS_7823067815721 $T=-245 180 0 0 $X=-245 $Y=55
X2 2 Contact_CDNS_7823067815721 $T=295 180 0 0 $X=295 $Y=55
M0 2 3 1 1 pmos1v2hvt L=2e-07 W=2e-06 AD=6e-13 AS=6e-13 PD=2.6e-06 PS=2.6e-06 m=1 $X=0 $Y=0 $dt=2
.ends pmos1v2hvt_4_CDNS_7823067815732

* +++++++++++++++++++++++++++++++++++++++++++++++++++++++++ *
* Sub cell: AbutContact_CDNS_7823067815738                  *
* +++++++++++++++++++++++++++++++++++++++++++++++++++++++++ *
.subckt AbutContact_CDNS_7823067815738 1 2
** N=2 EP=2 FDC=0
.ends AbutContact_CDNS_7823067815738

* +++++++++++++++++++++++++++++++++++++++++++++++++++++++++ *
* Sub cell: pmos1v2hvt_4_CDNS_7823067815736                 *
* +++++++++++++++++++++++++++++++++++++++++++++++++++++++++ *
.subckt pmos1v2hvt_4_CDNS_7823067815736 1 2 3 4 5
** N=5 EP=5 FDC=1
X0 1 Contact_CDNS_7823067815713 $T=-245 180 0 0 $X=-245 $Y=55
X1 2 Contact_CDNS_7823067815713 $T=2095 180 0 0 $X=2095 $Y=55
X2 1 Contact_CDNS_7823067815715 $T=-275 15 0 0 $X=-275 $Y=0
X3 2 Contact_CDNS_7823067815715 $T=2065 15 0 0 $X=2065 $Y=0
X4 4 5 AbutContact_CDNS_7823067815738 $T=-430 -560 0 0 $X=-520 $Y=-620
M0 2 3 1 4 pmos1v2hvt L=2e-06 W=8e-06 AD=2.4e-12 AS=2.4e-12 PD=8.6e-06 PS=8.6e-06 m=1 $X=0 $Y=0 $dt=2
.ends pmos1v2hvt_4_CDNS_7823067815736

* +++++++++++++++++++++++++++++++++++++++++++++++++++++++++ *
* Sub cell: pmos1v2hvt_4_CDNS_7823067815739                 *
* +++++++++++++++++++++++++++++++++++++++++++++++++++++++++ *
.subckt pmos1v2hvt_4_CDNS_7823067815739 1 2
** N=2 EP=2 FDC=1
X0 1 Contact_CDNS_7823067815713 $T=-245 180 0 0 $X=-245 $Y=55
X1 1 Contact_CDNS_7823067815713 $T=595 180 0 0 $X=595 $Y=55
X2 1 Contact_CDNS_7823067815715 $T=-275 15 0 0 $X=-275 $Y=0
X3 1 Contact_CDNS_7823067815715 $T=565 15 0 0 $X=565 $Y=0
X4 1 AbutContact_CDNS_7823067815722 $T=-430 -560 0 0 $X=-520 $Y=-620
X5 1 Contact_CDNS_7823067815731 $T=120 8140 0 0 $X=0 $Y=8140
M0 1 1 1 1 pmos1v2hvt L=5e-07 W=8e-06 AD=2.4e-12 AS=2.4e-12 PD=8.6e-06 PS=8.6e-06 m=1 $X=0 $Y=0 $dt=2
.ends pmos1v2hvt_4_CDNS_7823067815739

* +++++++++++++++++++++++++++++++++++++++++++++++++++++++++ *
* Sub cell: AbutContact_CDNS_7823067815742                  *
* +++++++++++++++++++++++++++++++++++++++++++++++++++++++++ *
.subckt AbutContact_CDNS_7823067815742 1
** N=1 EP=1 FDC=0
.ends AbutContact_CDNS_7823067815742

* +++++++++++++++++++++++++++++++++++++++++++++++++++++++++ *
* Sub cell: pmos1v2hvt_4_CDNS_7823067815740                 *
* +++++++++++++++++++++++++++++++++++++++++++++++++++++++++ *
.subckt pmos1v2hvt_4_CDNS_7823067815740 1 2
** N=2 EP=2 FDC=1
X0 1 Contact_CDNS_7823067815713 $T=-245 180 0 0 $X=-245 $Y=55
X1 1 Contact_CDNS_7823067815713 $T=1095 180 0 0 $X=1095 $Y=55
X2 1 AbutContact_CDNS_7823067815742 $T=-330 -560 0 0 $X=-520 $Y=-620
M0 1 1 1 1 pmos1v2hvt L=1e-06 W=8e-06 AD=2.4e-12 AS=2.4e-12 PD=8.6e-06 PS=8.6e-06 m=1 $X=0 $Y=0 $dt=2
.ends pmos1v2hvt_4_CDNS_7823067815740

* +++++++++++++++++++++++++++++++++++++++++++++++++++++++++ *
* Sub cell: Contact_CDNS_7823067815745                      *
* +++++++++++++++++++++++++++++++++++++++++++++++++++++++++ *
.subckt Contact_CDNS_7823067815745 1
** N=1 EP=1 FDC=0
.ends Contact_CDNS_7823067815745

* +++++++++++++++++++++++++++++++++++++++++++++++++++++++++ *
* Sub cell: nmos1v2hvt_4_CDNS_7823067815743                 *
* +++++++++++++++++++++++++++++++++++++++++++++++++++++++++ *
.subckt nmos1v2hvt_4_CDNS_7823067815743 1 2 3
** N=3 EP=3 FDC=2
X0 2 Contact_CDNS_7823067815721 $T=-245 180 0 0 $X=-245 $Y=55
X1 1 Contact_CDNS_7823067815721 $T=295 180 0 0 $X=295 $Y=55
X2 2 Contact_CDNS_7823067815721 $T=835 180 0 0 $X=835 $Y=55
X3 2 Contact_CDNS_7823067815745 $T=-275 165 0 0 $X=-275 $Y=0
X4 1 Contact_CDNS_7823067815745 $T=265 165 0 0 $X=265 $Y=0
X5 2 Contact_CDNS_7823067815745 $T=805 165 0 0 $X=805 $Y=0
M0 1 3 2 2 nmos1v2hvt L=2e-07 W=2e-06 AD=6.8e-13 AS=6e-13 PD=2.68e-06 PS=2.6e-06 m=1 $X=0 $Y=0 $dt=1
M1 2 3 1 2 nmos1v2hvt L=2e-07 W=2e-06 AD=6e-13 AS=6.8e-13 PD=2.6e-06 PS=2.68e-06 m=1 $X=540 $Y=0 $dt=1
.ends nmos1v2hvt_4_CDNS_7823067815743

* +++++++++++++++++++++++++++++++++++++++++++++++++++++++++ *
* Sub cell: BG_STARTUP_fL2                                  *
* +++++++++++++++++++++++++++++++++++++++++++++++++++++++++ *
.subckt BG_STARTUP_fL2 1 2 3 4 5 6 7 8
** N=14 EP=8 FDC=45
X0 1 PG_M1_CDNS_782306781578 $T=9770 49360 0 0 $X=9490 $Y=49080
X1 5 PG_M1_CDNS_782306781578 $T=16780 7265 0 0 $X=16500 $Y=6985
X2 5 PG_M1_CDNS_782306781578 $T=18520 7265 0 0 $X=18240 $Y=6985
X3 1 M1_M2_CDNS_7823067815710 $T=9770 49330 0 0 $X=9490 $Y=49020
X4 5 M1_M2_CDNS_7823067815710 $T=16780 7260 0 0 $X=16500 $Y=6950
X5 5 M1_M2_CDNS_7823067815710 $T=18520 7265 0 0 $X=18240 $Y=6955
X6 8 M1_M2_CDNS_7823067815710 $T=54255 6345 0 0 $X=53975 $Y=6035
X7 9 M1_M2_CDNS_7823067815711 $T=46470 9965 0 0 $X=46015 $Y=9480
X8 7 M1_M2_CDNS_7823067815711 $T=48275 12415 0 0 $X=47820 $Y=11930
X9 10 PG_M1_CDNS_7823067815717 $T=52230 9095 0 0 $X=52100 $Y=8815
X10 10 PG_M1_CDNS_7823067815717 $T=52475 7560 0 0 $X=52345 $Y=7280
X11 11 PG_M1_CDNS_7823067815717 $T=53910 7580 0 0 $X=53780 $Y=7300
X12 12 M2_M3_CDNS_7823067815732 $T=11730 16125 0 0 $X=11400 $Y=15580
X13 12 M2_M3_CDNS_7823067815732 $T=11730 36335 0 0 $X=11400 $Y=35790
X14 13 M2_M3_CDNS_7823067815732 $T=13610 14835 0 0 $X=13280 $Y=14290
X15 7 M2_M3_CDNS_7823067815732 $T=13610 37625 0 0 $X=13280 $Y=37080
X16 12 M2_M3_CDNS_7823067815732 $T=14995 41815 0 90 $X=14450 $Y=41485
X17 12 M2_M3_CDNS_7823067815732 $T=14970 16125 0 0 $X=14640 $Y=15580
X18 12 M2_M3_CDNS_7823067815732 $T=14970 36335 0 0 $X=14640 $Y=35790
X19 7 M2_M3_CDNS_7823067815732 $T=16850 13545 0 0 $X=16520 $Y=13000
X20 13 M2_M3_CDNS_7823067815732 $T=16850 38915 0 0 $X=16520 $Y=38370
X21 12 M2_M3_CDNS_7823067815732 $T=18210 16125 0 0 $X=17880 $Y=15580
X22 12 M2_M3_CDNS_7823067815732 $T=18210 36335 0 0 $X=17880 $Y=35790
X23 3 M2_M3_CDNS_7823067815732 $T=20235 43015 0 90 $X=19690 $Y=42685
X24 13 M2_M3_CDNS_7823067815732 $T=20550 14835 0 0 $X=20220 $Y=14290
X25 7 M2_M3_CDNS_7823067815732 $T=20550 37625 0 0 $X=20220 $Y=37080
X26 12 M2_M3_CDNS_7823067815732 $T=21450 16125 0 0 $X=21120 $Y=15580
X27 12 M2_M3_CDNS_7823067815732 $T=21450 36335 0 0 $X=21120 $Y=35790
X28 7 M2_M3_CDNS_7823067815732 $T=23330 13545 0 0 $X=23000 $Y=13000
X29 13 M2_M3_CDNS_7823067815732 $T=23330 38915 0 0 $X=23000 $Y=38370
X30 12 M2_M3_CDNS_7823067815732 $T=24690 16125 0 0 $X=24360 $Y=15580
X31 12 M2_M3_CDNS_7823067815732 $T=24690 36335 0 0 $X=24360 $Y=35790
X32 13 M2_M3_CDNS_7823067815732 $T=27030 14835 0 0 $X=26700 $Y=14290
X33 7 M2_M3_CDNS_7823067815732 $T=27030 37625 0 0 $X=26700 $Y=37080
X34 12 M2_M3_CDNS_7823067815732 $T=27930 16125 0 0 $X=27600 $Y=15580
X35 12 M2_M3_CDNS_7823067815732 $T=27930 36335 0 0 $X=27600 $Y=35790
X36 3 M2_M3_CDNS_7823067815732 $T=29825 43015 0 90 $X=29280 $Y=42685
X37 13 M2_M3_CDNS_7823067815732 $T=30270 14835 0 0 $X=29940 $Y=14290
X38 7 M2_M3_CDNS_7823067815732 $T=30270 37625 0 0 $X=29940 $Y=37080
X39 12 M2_M3_CDNS_7823067815732 $T=31170 16125 0 0 $X=30840 $Y=15580
X40 12 M2_M3_CDNS_7823067815732 $T=31170 36335 0 0 $X=30840 $Y=35790
X41 7 M2_M3_CDNS_7823067815732 $T=33050 13545 0 0 $X=32720 $Y=13000
X42 13 M2_M3_CDNS_7823067815732 $T=33050 38915 0 0 $X=32720 $Y=38370
X43 12 M2_M3_CDNS_7823067815732 $T=34410 16125 0 0 $X=34080 $Y=15580
X44 12 M2_M3_CDNS_7823067815732 $T=34410 36335 0 0 $X=34080 $Y=35790
X45 12 M2_M3_CDNS_7823067815732 $T=35065 41815 0 90 $X=34520 $Y=41485
X46 13 M2_M3_CDNS_7823067815732 $T=36750 14835 0 0 $X=36420 $Y=14290
X47 7 M2_M3_CDNS_7823067815732 $T=36750 37625 0 0 $X=36420 $Y=37080
X48 12 M2_M3_CDNS_7823067815732 $T=37650 16125 0 0 $X=37320 $Y=15580
X49 12 M2_M3_CDNS_7823067815732 $T=37650 36335 0 0 $X=37320 $Y=35790
X50 7 M2_M3_CDNS_7823067815732 $T=39530 13550 0 0 $X=39200 $Y=13005
X51 13 M2_M3_CDNS_7823067815732 $T=39530 38910 0 0 $X=39200 $Y=38365
X52 12 M2_M3_CDNS_7823067815732 $T=40890 16125 0 0 $X=40560 $Y=15580
X53 12 M2_M3_CDNS_7823067815732 $T=40890 36335 0 0 $X=40560 $Y=35790
X54 13 M2_M3_CDNS_7823067815732 $T=43230 14835 0 0 $X=42900 $Y=14290
X55 7 M2_M3_CDNS_7823067815732 $T=43230 37625 0 0 $X=42900 $Y=37080
X56 7 M2_M3_CDNS_7823067815735 $T=25830 13545 0 0 $X=24330 $Y=13000
X57 14 M1_M2_CDNS_7823067815753 $T=12670 25995 0 0 $X=12390 $Y=25860
X58 6 M1_M2_CDNS_7823067815753 $T=12670 26465 0 0 $X=12390 $Y=26330
X59 6 M1_M2_CDNS_7823067815753 $T=15190 26465 0 0 $X=14910 $Y=26330
X60 14 M1_M2_CDNS_7823067815753 $T=16630 25995 0 0 $X=16350 $Y=25860
X61 14 M1_M2_CDNS_7823067815753 $T=19150 25995 0 0 $X=18870 $Y=25860
X62 6 M1_M2_CDNS_7823067815753 $T=19150 26465 0 0 $X=18870 $Y=26330
X63 6 M1_M2_CDNS_7823067815753 $T=21670 26465 0 0 $X=21390 $Y=26330
X64 14 M1_M2_CDNS_7823067815753 $T=23110 25995 0 0 $X=22830 $Y=25860
X65 14 M1_M2_CDNS_7823067815753 $T=25630 25995 0 0 $X=25350 $Y=25860
X66 6 M1_M2_CDNS_7823067815753 $T=25630 26465 0 0 $X=25350 $Y=26330
X67 14 M1_M2_CDNS_7823067815753 $T=28870 25995 0 0 $X=28590 $Y=25860
X68 6 M1_M2_CDNS_7823067815753 $T=28870 26465 0 0 $X=28590 $Y=26330
X69 6 M1_M2_CDNS_7823067815753 $T=31390 26465 0 0 $X=31110 $Y=26330
X70 14 M1_M2_CDNS_7823067815753 $T=32830 25995 0 0 $X=32550 $Y=25860
X71 14 M1_M2_CDNS_7823067815753 $T=35350 25995 0 0 $X=35070 $Y=25860
X72 6 M1_M2_CDNS_7823067815753 $T=35350 26465 0 0 $X=35070 $Y=26330
X73 6 M1_M2_CDNS_7823067815753 $T=37870 26465 0 0 $X=37590 $Y=26330
X74 14 M1_M2_CDNS_7823067815753 $T=39310 25995 0 0 $X=39030 $Y=25860
X75 14 M1_M2_CDNS_7823067815753 $T=41830 25995 0 0 $X=41550 $Y=25860
X76 6 M1_M2_CDNS_7823067815753 $T=41830 26465 0 0 $X=41550 $Y=26330
X77 13 M2_M3_CDNS_7823067815754 $T=6210 14835 0 0 $X=5710 $Y=14290
X78 13 M2_M3_CDNS_7823067815754 $T=6210 38915 0 0 $X=5710 $Y=38370
X79 7 M2_M3_CDNS_7823067815754 $T=7410 13545 0 0 $X=6910 $Y=13000
X80 7 M2_M3_CDNS_7823067815754 $T=7410 37625 0 0 $X=6910 $Y=37080
X81 12 M2_M3_CDNS_7823067815754 $T=8610 16125 0 0 $X=8110 $Y=15580
X82 12 M2_M3_CDNS_7823067815754 $T=8610 36335 0 0 $X=8110 $Y=35790
X83 12 M2_M3_CDNS_7823067815754 $T=45890 16125 0 0 $X=45390 $Y=15580
X84 12 M2_M3_CDNS_7823067815754 $T=45890 36335 0 0 $X=45390 $Y=35790
X85 13 M2_M3_CDNS_7823067815754 $T=47090 14835 0 0 $X=46590 $Y=14290
X86 13 M2_M3_CDNS_7823067815754 $T=47090 38915 0 0 $X=46590 $Y=38370
X87 7 M2_M3_CDNS_7823067815754 $T=48290 13545 0 0 $X=47790 $Y=13000
X88 7 M2_M3_CDNS_7823067815754 $T=48290 37625 0 0 $X=47790 $Y=37080
X89 2 3 12 4 pmos1v2hvt_4_CDNS_7823067815712 $T=18720 51820 0 180 $X=14100 $Y=43420
X90 2 3 3 4 pmos1v2hvt_4_CDNS_7823067815712 $T=23960 51820 0 180 $X=19340 $Y=43420
X91 2 3 9 4 pmos1v2hvt_4_CDNS_7823067815712 $T=29200 51820 0 180 $X=24580 $Y=43420
X92 2 3 3 4 pmos1v2hvt_4_CDNS_7823067815712 $T=34440 51820 0 180 $X=29820 $Y=43420
X93 2 3 12 4 pmos1v2hvt_4_CDNS_7823067815712 $T=39680 51820 0 180 $X=35060 $Y=43420
X94 11 4 10 nmos1v2hvt_4_CDNS_7823067815717 $T=52370 5805 0 0 $X=51750 $Y=5085
X95 8 4 11 nmos1v2hvt_4_CDNS_7823067815717 $T=53810 5805 0 0 $X=53190 $Y=5085
X96 2 3 1 4 pmos1v2hvt_4_CDNS_7823067815720 $T=9520 51820 1 0 $X=8900 $Y=49420
X97 4 14 4 nmos1v2hvt_4_CDNS_7823067815723 $T=35920 6615 0 0 $X=35300 $Y=5895
X98 14 9 4 nmos1v2hvt_4_CDNS_7823067815723 $T=35920 9450 0 0 $X=35300 $Y=8730
X99 4 13 7 nmos1v2hvt_4_CDNS_7823067815726 $T=21640 6615 0 0 $X=21020 $Y=5895
X100 4 13 13 nmos1v2hvt_4_CDNS_7823067815726 $T=26880 6615 0 0 $X=26260 $Y=5895
X101 2 10 7 4 pmos1v2hvt_4_CDNS_7823067815730 $T=50390 11870 1 0 $X=49770 $Y=9470
X102 2 11 10 4 pmos1v2hvt_4_CDNS_7823067815732 $T=52130 11875 1 0 $X=51510 $Y=9465
X103 2 8 11 4 pmos1v2hvt_4_CDNS_7823067815732 $T=53570 11875 1 0 $X=52950 $Y=9465
X104 4 4 7 5 nmos1v2hvt_4_CDNS_7823067815734 $T=16530 5805 0 0 $X=15910 $Y=5085
X105 4 4 13 5 nmos1v2hvt_4_CDNS_7823067815734 $T=18270 5805 0 0 $X=17650 $Y=5085
X106 12 13 14 2 4 pmos1v2hvt_4_CDNS_7823067815736 $T=11670 17330 0 0 $X=11050 $Y=16610
X107 12 7 6 2 4 pmos1v2hvt_4_CDNS_7823067815736 $T=11670 35130 1 0 $X=11050 $Y=26730
X108 12 7 6 2 4 pmos1v2hvt_4_CDNS_7823067815736 $T=14910 17330 0 0 $X=14290 $Y=16610
X109 12 13 14 2 4 pmos1v2hvt_4_CDNS_7823067815736 $T=14910 35130 1 0 $X=14290 $Y=26730
X110 12 13 14 2 4 pmos1v2hvt_4_CDNS_7823067815736 $T=18150 17330 0 0 $X=17530 $Y=16610
X111 12 7 6 2 4 pmos1v2hvt_4_CDNS_7823067815736 $T=18150 35130 1 0 $X=17530 $Y=26730
X112 12 7 6 2 4 pmos1v2hvt_4_CDNS_7823067815736 $T=21390 17330 0 0 $X=20770 $Y=16610
X113 12 13 14 2 4 pmos1v2hvt_4_CDNS_7823067815736 $T=21390 35130 1 0 $X=20770 $Y=26730
X114 12 13 14 2 4 pmos1v2hvt_4_CDNS_7823067815736 $T=24630 17330 0 0 $X=24010 $Y=16610
X115 12 7 6 2 4 pmos1v2hvt_4_CDNS_7823067815736 $T=24630 35130 1 0 $X=24010 $Y=26730
X116 12 13 14 2 4 pmos1v2hvt_4_CDNS_7823067815736 $T=27870 17330 0 0 $X=27250 $Y=16610
X117 12 7 6 2 4 pmos1v2hvt_4_CDNS_7823067815736 $T=27870 35130 1 0 $X=27250 $Y=26730
X118 12 7 6 2 4 pmos1v2hvt_4_CDNS_7823067815736 $T=31110 17330 0 0 $X=30490 $Y=16610
X119 12 13 14 2 4 pmos1v2hvt_4_CDNS_7823067815736 $T=31110 35130 1 0 $X=30490 $Y=26730
X120 12 13 14 2 4 pmos1v2hvt_4_CDNS_7823067815736 $T=34350 17330 0 0 $X=33730 $Y=16610
X121 12 7 6 2 4 pmos1v2hvt_4_CDNS_7823067815736 $T=34350 35130 1 0 $X=33730 $Y=26730
X122 12 7 6 2 4 pmos1v2hvt_4_CDNS_7823067815736 $T=37590 17330 0 0 $X=36970 $Y=16610
X123 12 13 14 2 4 pmos1v2hvt_4_CDNS_7823067815736 $T=37590 35130 1 0 $X=36970 $Y=26730
X124 12 13 14 2 4 pmos1v2hvt_4_CDNS_7823067815736 $T=40830 17330 0 0 $X=40210 $Y=16610
X125 12 7 6 2 4 pmos1v2hvt_4_CDNS_7823067815736 $T=40830 35130 1 0 $X=40210 $Y=26730
X126 2 4 pmos1v2hvt_4_CDNS_7823067815739 $T=9930 17330 0 0 $X=9310 $Y=16610
X127 2 4 pmos1v2hvt_4_CDNS_7823067815739 $T=9930 35130 1 0 $X=9310 $Y=26730
X128 2 4 pmos1v2hvt_4_CDNS_7823067815739 $T=44070 17330 0 0 $X=43450 $Y=16610
X129 2 4 pmos1v2hvt_4_CDNS_7823067815739 $T=44070 35130 1 0 $X=43450 $Y=26730
X130 2 4 pmos1v2hvt_4_CDNS_7823067815740 $T=12480 51820 1 0 $X=11860 $Y=43420
X131 2 4 pmos1v2hvt_4_CDNS_7823067815740 $T=40920 51820 1 0 $X=40300 $Y=43420
X132 10 4 7 nmos1v2hvt_4_CDNS_7823067815743 $T=50390 5805 0 0 $X=49770 $Y=5085
.ends BG_STARTUP_fL2

* +++++++++++++++++++++++++++++++++++++++++++++++++++++++++ *
* Sub cell: nmos1v2hvt_4_CDNS_7823067815747                 *
* +++++++++++++++++++++++++++++++++++++++++++++++++++++++++ *
.subckt nmos1v2hvt_4_CDNS_7823067815747 1 2 3 4
** N=4 EP=4 FDC=1
X0 2 Contact_CDNS_7823067815721 $T=-245 180 0 0 $X=-245 $Y=55
X1 1 Contact_CDNS_7823067815721 $T=205 180 0 0 $X=205 $Y=55
M0 1 4 2 3 nmos1v2hvt L=1.1e-07 W=2e-06 AD=6e-13 AS=6e-13 PD=2.6e-06 PS=2.6e-06 m=1 $X=0 $Y=0 $dt=1
.ends nmos1v2hvt_4_CDNS_7823067815747

* +++++++++++++++++++++++++++++++++++++++++++++++++++++++++ *
* Sub cell: rnpolyh_CDNS_7823067815749                      *
* +++++++++++++++++++++++++++++++++++++++++++++++++++++++++ *
.subckt rnpolyh_CDNS_7823067815749 1 2 3 4
** N=4 EP=4 FDC=5
X0 1 Contact_CDNS_782306781576 $T=-30 -520 0 0 $X=-50 $Y=-540
X1 2 Contact_CDNS_782306781576 $T=-30 10260 0 0 $X=-50 $Y=10240
X2 1 Contact_CDNS_782306781576 $T=720 -520 0 0 $X=700 $Y=-540
X3 2 Contact_CDNS_782306781576 $T=720 10260 0 0 $X=700 $Y=10240
X4 1 Contact_CDNS_782306781576 $T=1470 -520 0 0 $X=1450 $Y=-540
X5 2 Contact_CDNS_782306781576 $T=1470 10260 0 0 $X=1450 $Y=10240
X6 1 Contact_CDNS_782306781576 $T=2220 -520 0 0 $X=2200 $Y=-540
X7 2 Contact_CDNS_782306781576 $T=2220 10260 0 0 $X=2200 $Y=10240
X8 1 Contact_CDNS_782306781576 $T=2970 -520 0 0 $X=2950 $Y=-540
X9 2 Contact_CDNS_782306781576 $T=2970 10260 0 0 $X=2950 $Y=10240
R0 1 2 37927.7 L=1e-05 W=5e-07 $[rnpolyh] $SUB=3 $X=0 $Y=0 $dt=3
R1 1 2 37927.7 L=1e-05 W=5e-07 $[rnpolyh] $SUB=3 $X=750 $Y=0 $dt=3
R2 1 2 37927.7 L=1e-05 W=5e-07 $[rnpolyh] $SUB=3 $X=1500 $Y=0 $dt=3
R3 1 2 37927.7 L=1e-05 W=5e-07 $[rnpolyh] $SUB=3 $X=2250 $Y=0 $dt=3
R4 1 2 37927.7 L=1e-05 W=5e-07 $[rnpolyh] $SUB=3 $X=3000 $Y=0 $dt=3
.ends rnpolyh_CDNS_7823067815749

* +++++++++++++++++++++++++++++++++++++++++++++++++++++++++ *
* Sub cell: rnpolyh_CDNS_7823067815750                      *
* +++++++++++++++++++++++++++++++++++++++++++++++++++++++++ *
.subckt rnpolyh_CDNS_7823067815750 1 2 3 4
** N=4 EP=4 FDC=2
X0 1 Contact_CDNS_782306781576 $T=-30 -520 0 0 $X=-50 $Y=-540
X1 2 Contact_CDNS_782306781576 $T=-30 10260 0 0 $X=-50 $Y=10240
X2 1 Contact_CDNS_782306781576 $T=720 -520 0 0 $X=700 $Y=-540
X3 2 Contact_CDNS_782306781576 $T=720 10260 0 0 $X=700 $Y=10240
R0 1 2 37927.7 L=1e-05 W=5e-07 $[rnpolyh] $SUB=3 $X=0 $Y=0 $dt=3
R1 1 2 37927.7 L=1e-05 W=5e-07 $[rnpolyh] $SUB=3 $X=750 $Y=0 $dt=3
.ends rnpolyh_CDNS_7823067815750

* +++++++++++++++++++++++++++++++++++++++++++++++++++++++++ *
* Sub cell: MASCO__Y2                                       *
* +++++++++++++++++++++++++++++++++++++++++++++++++++++++++ *
.subckt MASCO__Y2 1 2 3 4 5 6 7 8 9 10
+ 11
** N=11 EP=11 FDC=0
X0 11 Contact_CDNS_782306781576 $T=20 20 0 0 $X=0 $Y=0
X1 10 Contact_CDNS_782306781576 $T=770 20 0 0 $X=750 $Y=0
X2 9 Contact_CDNS_782306781576 $T=1520 20 0 0 $X=1500 $Y=0
X3 8 Contact_CDNS_782306781576 $T=2270 20 0 0 $X=2250 $Y=0
X4 7 Contact_CDNS_782306781576 $T=3020 20 0 0 $X=3000 $Y=0
X5 6 Contact_CDNS_782306781576 $T=3770 20 0 0 $X=3750 $Y=0
X6 5 Contact_CDNS_782306781576 $T=4520 20 0 0 $X=4500 $Y=0
X7 4 Contact_CDNS_782306781576 $T=5270 20 0 0 $X=5250 $Y=0
X8 3 Contact_CDNS_782306781576 $T=6020 20 0 0 $X=6000 $Y=0
X9 2 Contact_CDNS_782306781576 $T=6770 20 0 0 $X=6750 $Y=0
X10 1 Contact_CDNS_782306781576 $T=7520 20 0 0 $X=7500 $Y=0
.ends MASCO__Y2

* +++++++++++++++++++++++++++++++++++++++++++++++++++++++++ *
* Sub cell: rnpolyh_CDNS_7823067815751                      *
* +++++++++++++++++++++++++++++++++++++++++++++++++++++++++ *
.subckt rnpolyh_CDNS_7823067815751 1 2 3 4
** N=47 EP=4 FDC=44
X0 5 5 6 6 7 7 8 8 9 9
+ 2 MASCO__Y2 $T=-50 -540 0 0 $X=-50 $Y=-540
X1 10 11 11 12 12 13 13 14 14 15
+ 15 MASCO__Y2 $T=-50 10240 0 0 $X=-50 $Y=10240
X2 16 17 17 18 18 19 19 20 20 21
+ 21 MASCO__Y2 $T=8200 -540 0 0 $X=8200 $Y=-540
X3 22 22 23 23 24 24 25 25 26 26
+ 10 MASCO__Y2 $T=8200 10240 0 0 $X=8200 $Y=10240
X4 27 27 28 28 29 29 30 30 31 31
+ 16 MASCO__Y2 $T=16450 -540 0 0 $X=16450 $Y=-540
X5 32 33 33 34 34 35 35 36 36 37
+ 37 MASCO__Y2 $T=16450 10240 0 0 $X=16450 $Y=10240
X6 1 38 38 39 39 40 40 41 41 42
+ 42 MASCO__Y2 $T=24700 -540 0 0 $X=24700 $Y=-540
X7 43 43 44 44 45 45 46 46 47 47
+ 32 MASCO__Y2 $T=24700 10240 0 0 $X=24700 $Y=10240
R0 2 15 37927.7 L=1e-05 W=5e-07 $[rnpolyh] $SUB=3 $X=0 $Y=0 $dt=3
R1 9 15 37927.7 L=1e-05 W=5e-07 $[rnpolyh] $SUB=3 $X=750 $Y=0 $dt=3
R2 9 14 37927.7 L=1e-05 W=5e-07 $[rnpolyh] $SUB=3 $X=1500 $Y=0 $dt=3
R3 8 14 37927.7 L=1e-05 W=5e-07 $[rnpolyh] $SUB=3 $X=2250 $Y=0 $dt=3
R4 8 13 37927.7 L=1e-05 W=5e-07 $[rnpolyh] $SUB=3 $X=3000 $Y=0 $dt=3
R5 7 13 37927.7 L=1e-05 W=5e-07 $[rnpolyh] $SUB=3 $X=3750 $Y=0 $dt=3
R6 7 12 37927.7 L=1e-05 W=5e-07 $[rnpolyh] $SUB=3 $X=4500 $Y=0 $dt=3
R7 6 12 37927.7 L=1e-05 W=5e-07 $[rnpolyh] $SUB=3 $X=5250 $Y=0 $dt=3
R8 6 11 37927.7 L=1e-05 W=5e-07 $[rnpolyh] $SUB=3 $X=6000 $Y=0 $dt=3
R9 5 11 37927.7 L=1e-05 W=5e-07 $[rnpolyh] $SUB=3 $X=6750 $Y=0 $dt=3
R10 5 10 37927.7 L=1e-05 W=5e-07 $[rnpolyh] $SUB=3 $X=7500 $Y=0 $dt=3
R11 21 10 37927.7 L=1e-05 W=5e-07 $[rnpolyh] $SUB=3 $X=8250 $Y=0 $dt=3
R12 21 26 37927.7 L=1e-05 W=5e-07 $[rnpolyh] $SUB=3 $X=9000 $Y=0 $dt=3
R13 20 26 37927.7 L=1e-05 W=5e-07 $[rnpolyh] $SUB=3 $X=9750 $Y=0 $dt=3
R14 20 25 37927.7 L=1e-05 W=5e-07 $[rnpolyh] $SUB=3 $X=10500 $Y=0 $dt=3
R15 19 25 37927.7 L=1e-05 W=5e-07 $[rnpolyh] $SUB=3 $X=11250 $Y=0 $dt=3
R16 19 24 37927.7 L=1e-05 W=5e-07 $[rnpolyh] $SUB=3 $X=12000 $Y=0 $dt=3
R17 18 24 37927.7 L=1e-05 W=5e-07 $[rnpolyh] $SUB=3 $X=12750 $Y=0 $dt=3
R18 18 23 37927.7 L=1e-05 W=5e-07 $[rnpolyh] $SUB=3 $X=13500 $Y=0 $dt=3
R19 17 23 37927.7 L=1e-05 W=5e-07 $[rnpolyh] $SUB=3 $X=14250 $Y=0 $dt=3
R20 17 22 37927.7 L=1e-05 W=5e-07 $[rnpolyh] $SUB=3 $X=15000 $Y=0 $dt=3
R21 16 22 37927.7 L=1e-05 W=5e-07 $[rnpolyh] $SUB=3 $X=15750 $Y=0 $dt=3
R22 16 37 37927.7 L=1e-05 W=5e-07 $[rnpolyh] $SUB=3 $X=16500 $Y=0 $dt=3
R23 31 37 37927.7 L=1e-05 W=5e-07 $[rnpolyh] $SUB=3 $X=17250 $Y=0 $dt=3
R24 31 36 37927.7 L=1e-05 W=5e-07 $[rnpolyh] $SUB=3 $X=18000 $Y=0 $dt=3
R25 30 36 37927.7 L=1e-05 W=5e-07 $[rnpolyh] $SUB=3 $X=18750 $Y=0 $dt=3
R26 30 35 37927.7 L=1e-05 W=5e-07 $[rnpolyh] $SUB=3 $X=19500 $Y=0 $dt=3
R27 29 35 37927.7 L=1e-05 W=5e-07 $[rnpolyh] $SUB=3 $X=20250 $Y=0 $dt=3
R28 29 34 37927.7 L=1e-05 W=5e-07 $[rnpolyh] $SUB=3 $X=21000 $Y=0 $dt=3
R29 28 34 37927.7 L=1e-05 W=5e-07 $[rnpolyh] $SUB=3 $X=21750 $Y=0 $dt=3
R30 28 33 37927.7 L=1e-05 W=5e-07 $[rnpolyh] $SUB=3 $X=22500 $Y=0 $dt=3
R31 27 33 37927.7 L=1e-05 W=5e-07 $[rnpolyh] $SUB=3 $X=23250 $Y=0 $dt=3
R32 27 32 37927.7 L=1e-05 W=5e-07 $[rnpolyh] $SUB=3 $X=24000 $Y=0 $dt=3
R33 42 32 37927.7 L=1e-05 W=5e-07 $[rnpolyh] $SUB=3 $X=24750 $Y=0 $dt=3
R34 42 47 37927.7 L=1e-05 W=5e-07 $[rnpolyh] $SUB=3 $X=25500 $Y=0 $dt=3
R35 41 47 37927.7 L=1e-05 W=5e-07 $[rnpolyh] $SUB=3 $X=26250 $Y=0 $dt=3
R36 41 46 37927.7 L=1e-05 W=5e-07 $[rnpolyh] $SUB=3 $X=27000 $Y=0 $dt=3
R37 40 46 37927.7 L=1e-05 W=5e-07 $[rnpolyh] $SUB=3 $X=27750 $Y=0 $dt=3
R38 40 45 37927.7 L=1e-05 W=5e-07 $[rnpolyh] $SUB=3 $X=28500 $Y=0 $dt=3
R39 39 45 37927.7 L=1e-05 W=5e-07 $[rnpolyh] $SUB=3 $X=29250 $Y=0 $dt=3
R40 39 44 37927.7 L=1e-05 W=5e-07 $[rnpolyh] $SUB=3 $X=30000 $Y=0 $dt=3
R41 38 44 37927.7 L=1e-05 W=5e-07 $[rnpolyh] $SUB=3 $X=30750 $Y=0 $dt=3
R42 38 43 37927.7 L=1e-05 W=5e-07 $[rnpolyh] $SUB=3 $X=31500 $Y=0 $dt=3
R43 1 43 37927.7 L=1e-05 W=5e-07 $[rnpolyh] $SUB=3 $X=32250 $Y=0 $dt=3
.ends rnpolyh_CDNS_7823067815751

* +++++++++++++++++++++++++++++++++++++++++++++++++++++++++ *
* Sub cell: rnpolyh_CDNS_7823067815752                      *
* +++++++++++++++++++++++++++++++++++++++++++++++++++++++++ *
.subckt rnpolyh_CDNS_7823067815752 1 2 3 4
** N=4 EP=4 FDC=1
X0 1 Contact_CDNS_782306781576 $T=-30 -520 0 0 $X=-50 $Y=-540
X1 2 Contact_CDNS_782306781576 $T=-30 10260 0 0 $X=-50 $Y=10240
R0 1 2 37927.7 L=1e-05 W=5e-07 $[rnpolyh] $SUB=3 $X=0 $Y=0 $dt=3
.ends rnpolyh_CDNS_7823067815752

* +++++++++++++++++++++++++++++++++++++++++++++++++++++++++ *
* Sub cell: trim_res_bg_2_fL                                *
* +++++++++++++++++++++++++++++++++++++++++++++++++++++++++ *
.subckt trim_res_bg_2_fL 1 2 3 4 5 6 7 8 9 10
+ 11 12
** N=15 EP=12 FDC=100
X0 3 5 1 12 rnpolyh_CDNS_7823067815749 $T=7665 11655 0 180 $X=3915 $Y=915
X1 4 3 1 12 rnpolyh_CDNS_7823067815749 $T=11415 1655 1 180 $X=7665 $Y=915
X2 6 4 1 12 rnpolyh_CDNS_7823067815749 $T=15165 11655 0 180 $X=11415 $Y=915
X3 7 6 1 12 rnpolyh_CDNS_7823067815749 $T=18915 1655 1 180 $X=15165 $Y=915
X4 8 7 1 12 rnpolyh_CDNS_7823067815749 $T=22665 11655 0 180 $X=18915 $Y=915
X5 9 8 1 12 rnpolyh_CDNS_7823067815749 $T=26415 1655 1 180 $X=22665 $Y=915
X6 10 9 1 12 rnpolyh_CDNS_7823067815749 $T=30165 11655 0 180 $X=26415 $Y=915
X7 11 10 1 12 rnpolyh_CDNS_7823067815749 $T=33915 1655 1 180 $X=30165 $Y=915
X8 13 11 1 12 rnpolyh_CDNS_7823067815749 $T=37665 11655 0 180 $X=33915 $Y=915
X9 14 15 1 12 rnpolyh_CDNS_7823067815750 $T=34915 13055 0 0 $X=34665 $Y=12315
X10 15 13 1 12 rnpolyh_CDNS_7823067815750 $T=36415 23055 1 0 $X=36165 $Y=12315
X11 14 2 1 12 rnpolyh_CDNS_7823067815751 $T=1915 13055 0 0 $X=1665 $Y=12315
X12 1 1 1 12 rnpolyh_CDNS_7823067815752 $T=1665 1655 1 180 $X=915 $Y=915
X13 1 1 1 12 rnpolyh_CDNS_7823067815752 $T=1165 13055 0 0 $X=915 $Y=12315
X14 1 1 1 12 rnpolyh_CDNS_7823067815752 $T=2415 1655 1 180 $X=1665 $Y=915
X15 1 1 1 12 rnpolyh_CDNS_7823067815752 $T=3165 1655 1 180 $X=2415 $Y=915
X16 1 1 1 12 rnpolyh_CDNS_7823067815752 $T=3915 1655 1 180 $X=3165 $Y=915
X17 1 1 1 12 rnpolyh_CDNS_7823067815752 $T=38415 1655 1 180 $X=37665 $Y=915
X18 1 1 1 12 rnpolyh_CDNS_7823067815752 $T=37915 13055 0 0 $X=37665 $Y=12315
.ends trim_res_bg_2_fL

* +++++++++++++++++++++++++++++++++++++++++++++++++++++++++ *
* Sub cell: MASCO__Y1                                       *
* +++++++++++++++++++++++++++++++++++++++++++++++++++++++++ *
.subckt MASCO__Y1 1 2 3 4 5 6 7 8 9 10
+ 11 12
** N=12 EP=12 FDC=0
X0 12 Contact_CDNS_782306781576 $T=20 20 0 0 $X=0 $Y=0
X1 11 Contact_CDNS_782306781576 $T=770 20 0 0 $X=750 $Y=0
X2 10 Contact_CDNS_782306781576 $T=1520 20 0 0 $X=1500 $Y=0
X3 9 Contact_CDNS_782306781576 $T=2270 20 0 0 $X=2250 $Y=0
X4 8 Contact_CDNS_782306781576 $T=3020 20 0 0 $X=3000 $Y=0
X5 7 Contact_CDNS_782306781576 $T=3770 20 0 0 $X=3750 $Y=0
X6 6 Contact_CDNS_782306781576 $T=4520 20 0 0 $X=4500 $Y=0
X7 5 Contact_CDNS_782306781576 $T=5270 20 0 0 $X=5250 $Y=0
X8 4 Contact_CDNS_782306781576 $T=6020 20 0 0 $X=6000 $Y=0
X9 3 Contact_CDNS_782306781576 $T=6770 20 0 0 $X=6750 $Y=0
X10 2 Contact_CDNS_782306781576 $T=7520 20 0 0 $X=7500 $Y=0
X11 1 Contact_CDNS_782306781576 $T=8270 20 0 0 $X=8250 $Y=0
.ends MASCO__Y1

* +++++++++++++++++++++++++++++++++++++++++++++++++++++++++ *
* Sub cell: trim_res_bg_sl_fL                               *
* +++++++++++++++++++++++++++++++++++++++++++++++++++++++++ *
.subckt trim_res_bg_sl_fL 1 2 3 4 5 6 7 8 9 10
+ 11 12
** N=98 EP=12 FDC=97
X0 13 Contact_CDNS_782306781576 $T=64890 1140 0 0 $X=64870 $Y=1120
X1 14 Contact_CDNS_782306781576 $T=64890 11920 0 0 $X=64870 $Y=11900
X2 15 Contact_CDNS_782306781576 $T=65640 1140 0 0 $X=65620 $Y=1120
X3 14 Contact_CDNS_782306781576 $T=65640 11920 0 0 $X=65620 $Y=11900
X4 1 12 rnpolyh_CDNS_782306781575 $T=1170 1660 0 0 $X=920 $Y=920
X5 1 12 rnpolyh_CDNS_782306781575 $T=73170 1660 0 0 $X=72920 $Y=920
X6 15 3 1 12 rnpolyh_CDNS_7823067815752 $T=66420 1660 0 0 $X=66170 $Y=920
X7 3 4 1 12 rnpolyh_CDNS_7823067815752 $T=67670 11660 0 180 $X=66920 $Y=920
X8 4 5 1 12 rnpolyh_CDNS_7823067815752 $T=67920 1660 0 0 $X=67670 $Y=920
X9 5 6 1 12 rnpolyh_CDNS_7823067815752 $T=68670 11660 1 0 $X=68420 $Y=920
X10 6 7 1 12 rnpolyh_CDNS_7823067815752 $T=69420 1660 0 0 $X=69170 $Y=920
X11 7 8 1 12 rnpolyh_CDNS_7823067815752 $T=70170 11660 1 0 $X=69920 $Y=920
X12 8 9 1 12 rnpolyh_CDNS_7823067815752 $T=70920 1660 0 0 $X=70670 $Y=920
X13 9 10 1 12 rnpolyh_CDNS_7823067815752 $T=71670 11660 1 0 $X=71420 $Y=920
X14 10 11 1 12 rnpolyh_CDNS_7823067815752 $T=72420 1660 0 0 $X=72170 $Y=920
X15 16 17 17 18 18 19 19 20 20 21
+ 21 2 MASCO__Y1 $T=1870 1120 0 0 $X=1870 $Y=1120
X16 22 22 23 23 24 24 25 25 26 26
+ 27 27 MASCO__Y1 $T=1870 11900 0 0 $X=1870 $Y=11900
X17 28 29 29 30 30 31 31 32 32 33
+ 33 16 MASCO__Y1 $T=10870 1120 0 0 $X=10870 $Y=1120
X18 34 34 35 35 36 36 37 37 38 38
+ 39 39 MASCO__Y1 $T=10870 11900 0 0 $X=10870 $Y=11900
X19 40 41 41 42 42 43 43 44 44 45
+ 45 28 MASCO__Y1 $T=19870 1120 0 0 $X=19870 $Y=1120
X20 46 46 47 47 48 48 49 49 50 50
+ 51 51 MASCO__Y1 $T=19870 11900 0 0 $X=19870 $Y=11900
X21 52 53 53 54 54 55 55 56 56 57
+ 57 40 MASCO__Y1 $T=28870 1120 0 0 $X=28870 $Y=1120
X22 58 58 59 59 60 60 61 61 62 62
+ 63 63 MASCO__Y1 $T=28870 11900 0 0 $X=28870 $Y=11900
X23 64 65 65 66 66 67 67 68 68 69
+ 69 52 MASCO__Y1 $T=37870 1120 0 0 $X=37870 $Y=1120
X24 70 70 71 71 72 72 73 73 74 74
+ 75 75 MASCO__Y1 $T=37870 11900 0 0 $X=37870 $Y=11900
X25 76 77 77 78 78 79 79 80 80 81
+ 81 64 MASCO__Y1 $T=46870 1120 0 0 $X=46870 $Y=1120
X26 82 82 83 83 84 84 85 85 86 86
+ 87 87 MASCO__Y1 $T=46870 11900 0 0 $X=46870 $Y=11900
X27 13 88 88 89 89 90 90 91 91 92
+ 92 76 MASCO__Y1 $T=55870 1120 0 0 $X=55870 $Y=1120
X28 93 93 94 94 95 95 96 96 97 97
+ 98 98 MASCO__Y1 $T=55870 11900 0 0 $X=55870 $Y=11900
R0 2 27 37927.7 L=1e-05 W=5e-07 $[rnpolyh] $SUB=1 $X=1920 $Y=1660 $dt=3
R1 21 27 37927.7 L=1e-05 W=5e-07 $[rnpolyh] $SUB=1 $X=2670 $Y=1660 $dt=3
R2 21 26 37927.7 L=1e-05 W=5e-07 $[rnpolyh] $SUB=1 $X=3420 $Y=1660 $dt=3
R3 20 26 37927.7 L=1e-05 W=5e-07 $[rnpolyh] $SUB=1 $X=4170 $Y=1660 $dt=3
R4 20 25 37927.7 L=1e-05 W=5e-07 $[rnpolyh] $SUB=1 $X=4920 $Y=1660 $dt=3
R5 19 25 37927.7 L=1e-05 W=5e-07 $[rnpolyh] $SUB=1 $X=5670 $Y=1660 $dt=3
R6 19 24 37927.7 L=1e-05 W=5e-07 $[rnpolyh] $SUB=1 $X=6420 $Y=1660 $dt=3
R7 18 24 37927.7 L=1e-05 W=5e-07 $[rnpolyh] $SUB=1 $X=7170 $Y=1660 $dt=3
R8 18 23 37927.7 L=1e-05 W=5e-07 $[rnpolyh] $SUB=1 $X=7920 $Y=1660 $dt=3
R9 17 23 37927.7 L=1e-05 W=5e-07 $[rnpolyh] $SUB=1 $X=8670 $Y=1660 $dt=3
R10 17 22 37927.7 L=1e-05 W=5e-07 $[rnpolyh] $SUB=1 $X=9420 $Y=1660 $dt=3
R11 16 22 37927.7 L=1e-05 W=5e-07 $[rnpolyh] $SUB=1 $X=10170 $Y=1660 $dt=3
R12 16 39 37927.7 L=1e-05 W=5e-07 $[rnpolyh] $SUB=1 $X=10920 $Y=1660 $dt=3
R13 33 39 37927.7 L=1e-05 W=5e-07 $[rnpolyh] $SUB=1 $X=11670 $Y=1660 $dt=3
R14 33 38 37927.7 L=1e-05 W=5e-07 $[rnpolyh] $SUB=1 $X=12420 $Y=1660 $dt=3
R15 32 38 37927.7 L=1e-05 W=5e-07 $[rnpolyh] $SUB=1 $X=13170 $Y=1660 $dt=3
R16 32 37 37927.7 L=1e-05 W=5e-07 $[rnpolyh] $SUB=1 $X=13920 $Y=1660 $dt=3
R17 31 37 37927.7 L=1e-05 W=5e-07 $[rnpolyh] $SUB=1 $X=14670 $Y=1660 $dt=3
R18 31 36 37927.7 L=1e-05 W=5e-07 $[rnpolyh] $SUB=1 $X=15420 $Y=1660 $dt=3
R19 30 36 37927.7 L=1e-05 W=5e-07 $[rnpolyh] $SUB=1 $X=16170 $Y=1660 $dt=3
R20 30 35 37927.7 L=1e-05 W=5e-07 $[rnpolyh] $SUB=1 $X=16920 $Y=1660 $dt=3
R21 29 35 37927.7 L=1e-05 W=5e-07 $[rnpolyh] $SUB=1 $X=17670 $Y=1660 $dt=3
R22 29 34 37927.7 L=1e-05 W=5e-07 $[rnpolyh] $SUB=1 $X=18420 $Y=1660 $dt=3
R23 28 34 37927.7 L=1e-05 W=5e-07 $[rnpolyh] $SUB=1 $X=19170 $Y=1660 $dt=3
R24 28 51 37927.7 L=1e-05 W=5e-07 $[rnpolyh] $SUB=1 $X=19920 $Y=1660 $dt=3
R25 45 51 37927.7 L=1e-05 W=5e-07 $[rnpolyh] $SUB=1 $X=20670 $Y=1660 $dt=3
R26 45 50 37927.7 L=1e-05 W=5e-07 $[rnpolyh] $SUB=1 $X=21420 $Y=1660 $dt=3
R27 44 50 37927.7 L=1e-05 W=5e-07 $[rnpolyh] $SUB=1 $X=22170 $Y=1660 $dt=3
R28 44 49 37927.7 L=1e-05 W=5e-07 $[rnpolyh] $SUB=1 $X=22920 $Y=1660 $dt=3
R29 43 49 37927.7 L=1e-05 W=5e-07 $[rnpolyh] $SUB=1 $X=23670 $Y=1660 $dt=3
R30 43 48 37927.7 L=1e-05 W=5e-07 $[rnpolyh] $SUB=1 $X=24420 $Y=1660 $dt=3
R31 42 48 37927.7 L=1e-05 W=5e-07 $[rnpolyh] $SUB=1 $X=25170 $Y=1660 $dt=3
R32 42 47 37927.7 L=1e-05 W=5e-07 $[rnpolyh] $SUB=1 $X=25920 $Y=1660 $dt=3
R33 41 47 37927.7 L=1e-05 W=5e-07 $[rnpolyh] $SUB=1 $X=26670 $Y=1660 $dt=3
R34 41 46 37927.7 L=1e-05 W=5e-07 $[rnpolyh] $SUB=1 $X=27420 $Y=1660 $dt=3
R35 40 46 37927.7 L=1e-05 W=5e-07 $[rnpolyh] $SUB=1 $X=28170 $Y=1660 $dt=3
R36 40 63 37927.7 L=1e-05 W=5e-07 $[rnpolyh] $SUB=1 $X=28920 $Y=1660 $dt=3
R37 57 63 37927.7 L=1e-05 W=5e-07 $[rnpolyh] $SUB=1 $X=29670 $Y=1660 $dt=3
R38 57 62 37927.7 L=1e-05 W=5e-07 $[rnpolyh] $SUB=1 $X=30420 $Y=1660 $dt=3
R39 56 62 37927.7 L=1e-05 W=5e-07 $[rnpolyh] $SUB=1 $X=31170 $Y=1660 $dt=3
R40 56 61 37927.7 L=1e-05 W=5e-07 $[rnpolyh] $SUB=1 $X=31920 $Y=1660 $dt=3
R41 55 61 37927.7 L=1e-05 W=5e-07 $[rnpolyh] $SUB=1 $X=32670 $Y=1660 $dt=3
R42 55 60 37927.7 L=1e-05 W=5e-07 $[rnpolyh] $SUB=1 $X=33420 $Y=1660 $dt=3
R43 54 60 37927.7 L=1e-05 W=5e-07 $[rnpolyh] $SUB=1 $X=34170 $Y=1660 $dt=3
R44 54 59 37927.7 L=1e-05 W=5e-07 $[rnpolyh] $SUB=1 $X=34920 $Y=1660 $dt=3
R45 53 59 37927.7 L=1e-05 W=5e-07 $[rnpolyh] $SUB=1 $X=35670 $Y=1660 $dt=3
R46 53 58 37927.7 L=1e-05 W=5e-07 $[rnpolyh] $SUB=1 $X=36420 $Y=1660 $dt=3
R47 52 58 37927.7 L=1e-05 W=5e-07 $[rnpolyh] $SUB=1 $X=37170 $Y=1660 $dt=3
R48 52 75 37927.7 L=1e-05 W=5e-07 $[rnpolyh] $SUB=1 $X=37920 $Y=1660 $dt=3
R49 69 75 37927.7 L=1e-05 W=5e-07 $[rnpolyh] $SUB=1 $X=38670 $Y=1660 $dt=3
R50 69 74 37927.7 L=1e-05 W=5e-07 $[rnpolyh] $SUB=1 $X=39420 $Y=1660 $dt=3
R51 68 74 37927.7 L=1e-05 W=5e-07 $[rnpolyh] $SUB=1 $X=40170 $Y=1660 $dt=3
R52 68 73 37927.7 L=1e-05 W=5e-07 $[rnpolyh] $SUB=1 $X=40920 $Y=1660 $dt=3
R53 67 73 37927.7 L=1e-05 W=5e-07 $[rnpolyh] $SUB=1 $X=41670 $Y=1660 $dt=3
R54 67 72 37927.7 L=1e-05 W=5e-07 $[rnpolyh] $SUB=1 $X=42420 $Y=1660 $dt=3
R55 66 72 37927.7 L=1e-05 W=5e-07 $[rnpolyh] $SUB=1 $X=43170 $Y=1660 $dt=3
R56 66 71 37927.7 L=1e-05 W=5e-07 $[rnpolyh] $SUB=1 $X=43920 $Y=1660 $dt=3
R57 65 71 37927.7 L=1e-05 W=5e-07 $[rnpolyh] $SUB=1 $X=44670 $Y=1660 $dt=3
R58 65 70 37927.7 L=1e-05 W=5e-07 $[rnpolyh] $SUB=1 $X=45420 $Y=1660 $dt=3
R59 64 70 37927.7 L=1e-05 W=5e-07 $[rnpolyh] $SUB=1 $X=46170 $Y=1660 $dt=3
R60 64 87 37927.7 L=1e-05 W=5e-07 $[rnpolyh] $SUB=1 $X=46920 $Y=1660 $dt=3
R61 81 87 37927.7 L=1e-05 W=5e-07 $[rnpolyh] $SUB=1 $X=47670 $Y=1660 $dt=3
R62 81 86 37927.7 L=1e-05 W=5e-07 $[rnpolyh] $SUB=1 $X=48420 $Y=1660 $dt=3
R63 80 86 37927.7 L=1e-05 W=5e-07 $[rnpolyh] $SUB=1 $X=49170 $Y=1660 $dt=3
R64 80 85 37927.7 L=1e-05 W=5e-07 $[rnpolyh] $SUB=1 $X=49920 $Y=1660 $dt=3
R65 79 85 37927.7 L=1e-05 W=5e-07 $[rnpolyh] $SUB=1 $X=50670 $Y=1660 $dt=3
R66 79 84 37927.7 L=1e-05 W=5e-07 $[rnpolyh] $SUB=1 $X=51420 $Y=1660 $dt=3
R67 78 84 37927.7 L=1e-05 W=5e-07 $[rnpolyh] $SUB=1 $X=52170 $Y=1660 $dt=3
R68 78 83 37927.7 L=1e-05 W=5e-07 $[rnpolyh] $SUB=1 $X=52920 $Y=1660 $dt=3
R69 77 83 37927.7 L=1e-05 W=5e-07 $[rnpolyh] $SUB=1 $X=53670 $Y=1660 $dt=3
R70 77 82 37927.7 L=1e-05 W=5e-07 $[rnpolyh] $SUB=1 $X=54420 $Y=1660 $dt=3
R71 76 82 37927.7 L=1e-05 W=5e-07 $[rnpolyh] $SUB=1 $X=55170 $Y=1660 $dt=3
R72 76 98 37927.7 L=1e-05 W=5e-07 $[rnpolyh] $SUB=1 $X=55920 $Y=1660 $dt=3
R73 92 98 37927.7 L=1e-05 W=5e-07 $[rnpolyh] $SUB=1 $X=56670 $Y=1660 $dt=3
R74 92 97 37927.7 L=1e-05 W=5e-07 $[rnpolyh] $SUB=1 $X=57420 $Y=1660 $dt=3
R75 91 97 37927.7 L=1e-05 W=5e-07 $[rnpolyh] $SUB=1 $X=58170 $Y=1660 $dt=3
R76 91 96 37927.7 L=1e-05 W=5e-07 $[rnpolyh] $SUB=1 $X=58920 $Y=1660 $dt=3
R77 90 96 37927.7 L=1e-05 W=5e-07 $[rnpolyh] $SUB=1 $X=59670 $Y=1660 $dt=3
R78 90 95 37927.7 L=1e-05 W=5e-07 $[rnpolyh] $SUB=1 $X=60420 $Y=1660 $dt=3
R79 89 95 37927.7 L=1e-05 W=5e-07 $[rnpolyh] $SUB=1 $X=61170 $Y=1660 $dt=3
R80 89 94 37927.7 L=1e-05 W=5e-07 $[rnpolyh] $SUB=1 $X=61920 $Y=1660 $dt=3
R81 88 94 37927.7 L=1e-05 W=5e-07 $[rnpolyh] $SUB=1 $X=62670 $Y=1660 $dt=3
R82 88 93 37927.7 L=1e-05 W=5e-07 $[rnpolyh] $SUB=1 $X=63420 $Y=1660 $dt=3
R83 13 93 37927.7 L=1e-05 W=5e-07 $[rnpolyh] $SUB=1 $X=64170 $Y=1660 $dt=3
R84 13 14 37927.7 L=1e-05 W=5e-07 $[rnpolyh] $SUB=1 $X=64920 $Y=1660 $dt=3
R85 15 14 37927.7 L=1e-05 W=5e-07 $[rnpolyh] $SUB=1 $X=65670 $Y=1660 $dt=3
.ends trim_res_bg_sl_fL

* +++++++++++++++++++++++++++++++++++++++++++++++++++++++++ *
* Sub cell: Contact_CDNS_7823067815755                      *
* +++++++++++++++++++++++++++++++++++++++++++++++++++++++++ *
.subckt Contact_CDNS_7823067815755 1
** N=1 EP=1 FDC=0
.ends Contact_CDNS_7823067815755

* +++++++++++++++++++++++++++++++++++++++++++++++++++++++++ *
* Sub cell: pmos1v2hvt_4_CDNS_7823067815754                 *
* +++++++++++++++++++++++++++++++++++++++++++++++++++++++++ *
.subckt pmos1v2hvt_4_CDNS_7823067815754 1 2 3 4
** N=4 EP=4 FDC=1
X0 1 4 AbutContact_CDNS_7823067815738 $T=-430 -560 0 0 $X=-520 $Y=-620
X1 1 Contact_CDNS_7823067815755 $T=-245 60 0 0 $X=-245 $Y=0
X2 2 Contact_CDNS_7823067815755 $T=2095 60 0 0 $X=2095 $Y=0
M0 2 3 1 1 pmos1v2hvt L=2e-06 W=5.6e-07 AD=1.68e-13 AS=1.68e-13 PD=1.16e-06 PS=1.16e-06 m=1 $X=0 $Y=0 $dt=2
.ends pmos1v2hvt_4_CDNS_7823067815754

* +++++++++++++++++++++++++++++++++++++++++++++++++++++++++ *
* Sub cell: Contact_CDNS_7823067815757                      *
* +++++++++++++++++++++++++++++++++++++++++++++++++++++++++ *
.subckt Contact_CDNS_7823067815757 1
** N=1 EP=1 FDC=0
.ends Contact_CDNS_7823067815757

* +++++++++++++++++++++++++++++++++++++++++++++++++++++++++ *
* Sub cell: pmos1v2hvt_4_CDNS_7823067815756                 *
* +++++++++++++++++++++++++++++++++++++++++++++++++++++++++ *
.subckt pmos1v2hvt_4_CDNS_7823067815756 1 2 3 4
** N=4 EP=4 FDC=1
X0 3 AbutContact_CDNS_7823067815722 $T=-430 -560 0 0 $X=-520 $Y=-620
X1 1 Contact_CDNS_7823067815757 $T=-245 180 0 0 $X=-245 $Y=55
X2 2 Contact_CDNS_7823067815757 $T=595 180 0 0 $X=595 $Y=55
M0 2 2 1 3 pmos1v2hvt L=5e-07 W=5e-06 AD=1.5e-12 AS=1.5e-12 PD=5.6e-06 PS=5.6e-06 m=1 $X=0 $Y=0 $dt=2
.ends pmos1v2hvt_4_CDNS_7823067815756

* +++++++++++++++++++++++++++++++++++++++++++++++++++++++++ *
* Sub cell: Contact_CDNS_7823067815759                      *
* +++++++++++++++++++++++++++++++++++++++++++++++++++++++++ *
.subckt Contact_CDNS_7823067815759 1 2
** N=2 EP=2 FDC=0
.ends Contact_CDNS_7823067815759

* +++++++++++++++++++++++++++++++++++++++++++++++++++++++++ *
* Sub cell: Contact_CDNS_7823067815761                      *
* +++++++++++++++++++++++++++++++++++++++++++++++++++++++++ *
.subckt Contact_CDNS_7823067815761 1
** N=1 EP=1 FDC=0
.ends Contact_CDNS_7823067815761

* +++++++++++++++++++++++++++++++++++++++++++++++++++++++++ *
* Sub cell: Contact_CDNS_7823067815762                      *
* +++++++++++++++++++++++++++++++++++++++++++++++++++++++++ *
.subckt Contact_CDNS_7823067815762 1
** N=1 EP=1 FDC=0
.ends Contact_CDNS_7823067815762

* +++++++++++++++++++++++++++++++++++++++++++++++++++++++++ *
* Sub cell: pmos1v2hvt_4_CDNS_7823067815760                 *
* +++++++++++++++++++++++++++++++++++++++++++++++++++++++++ *
.subckt pmos1v2hvt_4_CDNS_7823067815760 1 2 3 4
** N=4 EP=4 FDC=1
X0 1 4 Contact_CDNS_7823067815759 $T=-245 130 0 0 $X=-245 $Y=0
X1 2 4 Contact_CDNS_7823067815759 $T=7595 130 0 0 $X=7595 $Y=0
X2 1 Contact_CDNS_7823067815761 $T=-275 90 0 0 $X=-275 $Y=0
X3 2 Contact_CDNS_7823067815761 $T=7565 90 0 0 $X=7565 $Y=0
X4 3 Contact_CDNS_7823067815762 $T=1220 40100 0 0 $X=1125 $Y=40100
M0 2 3 1 1 pmos1v2hvt L=7.5e-06 W=4e-05 AD=1.2e-11 AS=1.2e-11 PD=4.06e-05 PS=4.06e-05 m=1 $X=0 $Y=0 $dt=2
.ends pmos1v2hvt_4_CDNS_7823067815760

* +++++++++++++++++++++++++++++++++++++++++++++++++++++++++ *
* Sub cell: pmos1v2hvt_4_CDNS_7823067815766                 *
* +++++++++++++++++++++++++++++++++++++++++++++++++++++++++ *
.subckt pmos1v2hvt_4_CDNS_7823067815766 1 2 3 4 5
** N=5 EP=5 FDC=10
X0 2 Contact_CDNS_7823067815727 $T=-245 130 0 0 $X=-245 $Y=0
X1 3 Contact_CDNS_7823067815727 $T=595 130 0 0 $X=595 $Y=0
X2 2 Contact_CDNS_7823067815727 $T=1435 130 0 0 $X=1435 $Y=0
X3 3 Contact_CDNS_7823067815727 $T=2275 130 0 0 $X=2275 $Y=0
X4 2 Contact_CDNS_7823067815727 $T=3115 130 0 0 $X=3115 $Y=0
X5 3 Contact_CDNS_7823067815727 $T=3955 130 0 0 $X=3955 $Y=0
X6 2 Contact_CDNS_7823067815727 $T=4795 130 0 0 $X=4795 $Y=0
X7 3 Contact_CDNS_7823067815727 $T=5635 130 0 0 $X=5635 $Y=0
X8 2 Contact_CDNS_7823067815727 $T=6475 130 0 0 $X=6475 $Y=0
X9 3 Contact_CDNS_7823067815727 $T=7315 130 0 0 $X=7315 $Y=0
X10 2 Contact_CDNS_7823067815727 $T=8155 130 0 0 $X=8155 $Y=0
X11 2 Contact_CDNS_7823067815728 $T=-275 115 0 0 $X=-275 $Y=0
X12 3 Contact_CDNS_7823067815728 $T=565 115 0 0 $X=565 $Y=0
X13 2 Contact_CDNS_7823067815728 $T=1405 115 0 0 $X=1405 $Y=0
X14 3 Contact_CDNS_7823067815728 $T=2245 115 0 0 $X=2245 $Y=0
X15 2 Contact_CDNS_7823067815728 $T=3085 115 0 0 $X=3085 $Y=0
X16 3 Contact_CDNS_7823067815728 $T=3925 115 0 0 $X=3925 $Y=0
X17 2 Contact_CDNS_7823067815728 $T=4765 115 0 0 $X=4765 $Y=0
X18 3 Contact_CDNS_7823067815728 $T=5605 115 0 0 $X=5605 $Y=0
X19 2 Contact_CDNS_7823067815728 $T=6445 115 0 0 $X=6445 $Y=0
X20 3 Contact_CDNS_7823067815728 $T=7285 115 0 0 $X=7285 $Y=0
X21 2 Contact_CDNS_7823067815728 $T=8125 115 0 0 $X=8125 $Y=0
M0 3 4 2 1 pmos1v2hvt L=5e-07 W=4e-06 AD=1.36e-12 AS=1.2e-12 PD=4.68e-06 PS=4.6e-06 m=1 $X=0 $Y=0 $dt=2
M1 2 4 3 1 pmos1v2hvt L=5e-07 W=4e-06 AD=1.36e-12 AS=1.36e-12 PD=4.68e-06 PS=4.68e-06 m=1 $X=840 $Y=0 $dt=2
M2 3 4 2 1 pmos1v2hvt L=5e-07 W=4e-06 AD=1.36e-12 AS=1.36e-12 PD=4.68e-06 PS=4.68e-06 m=1 $X=1680 $Y=0 $dt=2
M3 2 4 3 1 pmos1v2hvt L=5e-07 W=4e-06 AD=1.36e-12 AS=1.36e-12 PD=4.68e-06 PS=4.68e-06 m=1 $X=2520 $Y=0 $dt=2
M4 3 4 2 1 pmos1v2hvt L=5e-07 W=4e-06 AD=1.36e-12 AS=1.36e-12 PD=4.68e-06 PS=4.68e-06 m=1 $X=3360 $Y=0 $dt=2
M5 2 4 3 1 pmos1v2hvt L=5e-07 W=4e-06 AD=1.36e-12 AS=1.36e-12 PD=4.68e-06 PS=4.68e-06 m=1 $X=4200 $Y=0 $dt=2
M6 3 4 2 1 pmos1v2hvt L=5e-07 W=4e-06 AD=1.36e-12 AS=1.36e-12 PD=4.68e-06 PS=4.68e-06 m=1 $X=5040 $Y=0 $dt=2
M7 2 4 3 1 pmos1v2hvt L=5e-07 W=4e-06 AD=1.36e-12 AS=1.36e-12 PD=4.68e-06 PS=4.68e-06 m=1 $X=5880 $Y=0 $dt=2
M8 3 4 2 1 pmos1v2hvt L=5e-07 W=4e-06 AD=1.36e-12 AS=1.36e-12 PD=4.68e-06 PS=4.68e-06 m=1 $X=6720 $Y=0 $dt=2
M9 2 4 3 1 pmos1v2hvt L=5e-07 W=4e-06 AD=1.2e-12 AS=1.36e-12 PD=4.6e-06 PS=4.68e-06 m=1 $X=7560 $Y=0 $dt=2
.ends pmos1v2hvt_4_CDNS_7823067815766

* +++++++++++++++++++++++++++++++++++++++++++++++++++++++++ *
* Sub cell: Contact_CDNS_7823067815775                      *
* +++++++++++++++++++++++++++++++++++++++++++++++++++++++++ *
.subckt Contact_CDNS_7823067815775 1 2
*.DEVICECLIMB
** N=2 EP=2 FDC=0
.ends Contact_CDNS_7823067815775

* +++++++++++++++++++++++++++++++++++++++++++++++++++++++++ *
* Sub cell: Contact_CDNS_7823067815776                      *
* +++++++++++++++++++++++++++++++++++++++++++++++++++++++++ *
.subckt Contact_CDNS_7823067815776 1
** N=1 EP=1 FDC=0
.ends Contact_CDNS_7823067815776

* +++++++++++++++++++++++++++++++++++++++++++++++++++++++++ *
* Sub cell: Contact_CDNS_7823067815777                      *
* +++++++++++++++++++++++++++++++++++++++++++++++++++++++++ *
.subckt Contact_CDNS_7823067815777 1
** N=1 EP=1 FDC=0
.ends Contact_CDNS_7823067815777

* +++++++++++++++++++++++++++++++++++++++++++++++++++++++++ *
* Sub cell: AbutContact_CDNS_7823067815778                  *
* +++++++++++++++++++++++++++++++++++++++++++++++++++++++++ *
.subckt AbutContact_CDNS_7823067815778 1
** N=1 EP=1 FDC=0
.ends AbutContact_CDNS_7823067815778

* +++++++++++++++++++++++++++++++++++++++++++++++++++++++++ *
* Sub cell: AbutContact_CDNS_7823067815779                  *
* +++++++++++++++++++++++++++++++++++++++++++++++++++++++++ *
.subckt AbutContact_CDNS_7823067815779 1
** N=1 EP=1 FDC=0
.ends AbutContact_CDNS_7823067815779

* +++++++++++++++++++++++++++++++++++++++++++++++++++++++++ *
* Sub cell: AbutContact_CDNS_7823067815780                  *
* +++++++++++++++++++++++++++++++++++++++++++++++++++++++++ *
.subckt AbutContact_CDNS_7823067815780 1
** N=1 EP=1 FDC=0
.ends AbutContact_CDNS_7823067815780

* +++++++++++++++++++++++++++++++++++++++++++++++++++++++++ *
* Sub cell: AbutContact_CDNS_7823067815781                  *
* +++++++++++++++++++++++++++++++++++++++++++++++++++++++++ *
.subckt AbutContact_CDNS_7823067815781 1
** N=1 EP=1 FDC=0
.ends AbutContact_CDNS_7823067815781

* +++++++++++++++++++++++++++++++++++++++++++++++++++++++++ *
* Sub cell: Contact_CDNS_7823067815782                      *
* +++++++++++++++++++++++++++++++++++++++++++++++++++++++++ *
.subckt Contact_CDNS_7823067815782 1
** N=1 EP=1 FDC=0
.ends Contact_CDNS_7823067815782

* +++++++++++++++++++++++++++++++++++++++++++++++++++++++++ *
* Sub cell: pnp5ux5u_CDNS_7823067815774                     *
* +++++++++++++++++++++++++++++++++++++++++++++++++++++++++ *
.subckt pnp5ux5u_CDNS_7823067815774 1 2
*.DEVICECLIMB
** N=2 EP=2 FDC=0
X0 2 1 Contact_CDNS_7823067815775 $T=1620 1620 0 0 $X=1500 $Y=1500
X1 2 Contact_CDNS_7823067815776 $T=1665 1665 0 0 $X=1500 $Y=1500
X2 1 Contact_CDNS_7823067815777 $T=-780 -1150 0 0 $X=-860 $Y=-1180
X3 1 Contact_CDNS_7823067815777 $T=-780 5890 0 0 $X=-860 $Y=5860
X4 1 AbutContact_CDNS_7823067815778 $T=-130 -510 0 0 $X=-280 $Y=-600
X5 1 AbutContact_CDNS_7823067815778 $T=-130 5250 0 0 $X=-280 $Y=5160
X6 1 AbutContact_CDNS_7823067815779 $T=-510 -480 0 0 $X=-600 $Y=-600
X7 1 AbutContact_CDNS_7823067815779 $T=5250 -480 0 0 $X=5160 $Y=-600
X8 1 AbutContact_CDNS_7823067815780 $T=-860 -1180 0 0 $X=-1020 $Y=-1340
X9 1 AbutContact_CDNS_7823067815780 $T=-860 5860 0 0 $X=-1020 $Y=5700
X10 1 AbutContact_CDNS_7823067815781 $T=-1180 -1180 0 0 $X=-1340 $Y=-1340
X11 1 AbutContact_CDNS_7823067815781 $T=5860 -1180 0 0 $X=5700 $Y=-1340
X12 1 Contact_CDNS_7823067815782 $T=-1150 -780 0 0 $X=-1180 $Y=-860
X13 1 Contact_CDNS_7823067815782 $T=5890 -780 0 0 $X=5860 $Y=-860
.ends pnp5ux5u_CDNS_7823067815774

* +++++++++++++++++++++++++++++++++++++++++++++++++++++++++ *
* Sub cell: pnp5ux5u_CDNS_7823067815783                     *
* +++++++++++++++++++++++++++++++++++++++++++++++++++++++++ *
.subckt pnp5ux5u_CDNS_7823067815783 1 2
*.DEVICECLIMB
** N=2 EP=2 FDC=1
X0 2 1 Contact_CDNS_7823067815775 $T=1620 1620 0 0 $X=1500 $Y=1500
X1 2 Contact_CDNS_7823067815776 $T=1665 1665 0 0 $X=1500 $Y=1500
X2 1 Contact_CDNS_7823067815777 $T=-780 -1150 0 0 $X=-860 $Y=-1180
X3 1 Contact_CDNS_7823067815777 $T=-780 5890 0 0 $X=-860 $Y=5860
X4 1 AbutContact_CDNS_7823067815778 $T=-130 -510 0 0 $X=-280 $Y=-600
X5 1 AbutContact_CDNS_7823067815778 $T=-130 5250 0 0 $X=-280 $Y=5160
X6 1 AbutContact_CDNS_7823067815779 $T=-510 -480 0 0 $X=-600 $Y=-600
X7 1 AbutContact_CDNS_7823067815779 $T=5250 -480 0 0 $X=5160 $Y=-600
X8 1 AbutContact_CDNS_7823067815780 $T=-860 -1180 0 0 $X=-1020 $Y=-1340
X9 1 AbutContact_CDNS_7823067815780 $T=-860 5860 0 0 $X=-1020 $Y=5700
X10 1 AbutContact_CDNS_7823067815781 $T=-1180 -1180 0 0 $X=-1340 $Y=-1340
X11 1 AbutContact_CDNS_7823067815781 $T=5860 -1180 0 0 $X=5700 $Y=-1340
X12 1 Contact_CDNS_7823067815782 $T=-1150 -780 0 0 $X=-1180 $Y=-860
X13 1 Contact_CDNS_7823067815782 $T=5890 -780 0 0 $X=5860 $Y=-860
Q0 1 1 2 pnp5ux5u ae=2.5e-11 m=1 $X=-860 $Y=-860 $dt=4
.ends pnp5ux5u_CDNS_7823067815783

* +++++++++++++++++++++++++++++++++++++++++++++++++++++++++ *
* Sub cell: pnp5ux5u_CDNS_7823067815784                     *
* +++++++++++++++++++++++++++++++++++++++++++++++++++++++++ *
.subckt pnp5ux5u_CDNS_7823067815784 1 2
*.DEVICECLIMB
** N=2 EP=2 FDC=0
X0 2 1 Contact_CDNS_7823067815775 $T=1620 1620 0 0 $X=1500 $Y=1500
X1 2 Contact_CDNS_7823067815776 $T=1665 1665 0 0 $X=1500 $Y=1500
X2 1 Contact_CDNS_7823067815777 $T=-780 -1150 0 0 $X=-860 $Y=-1180
X3 1 Contact_CDNS_7823067815777 $T=-780 5890 0 0 $X=-860 $Y=5860
X4 1 AbutContact_CDNS_7823067815778 $T=-130 -510 0 0 $X=-280 $Y=-600
X5 1 AbutContact_CDNS_7823067815778 $T=-130 5250 0 0 $X=-280 $Y=5160
X6 1 AbutContact_CDNS_7823067815779 $T=-510 -480 0 0 $X=-600 $Y=-600
X7 1 AbutContact_CDNS_7823067815779 $T=5250 -480 0 0 $X=5160 $Y=-600
X8 1 AbutContact_CDNS_7823067815780 $T=-860 -1180 0 0 $X=-1020 $Y=-1340
X9 1 AbutContact_CDNS_7823067815780 $T=-860 5860 0 0 $X=-1020 $Y=5700
X10 1 AbutContact_CDNS_7823067815781 $T=-1180 -1180 0 0 $X=-1340 $Y=-1340
X11 1 AbutContact_CDNS_7823067815781 $T=5860 -1180 0 0 $X=5700 $Y=-1340
X12 1 Contact_CDNS_7823067815782 $T=-1150 -780 0 0 $X=-1180 $Y=-860
X13 1 Contact_CDNS_7823067815782 $T=5890 -780 0 0 $X=5860 $Y=-860
.ends pnp5ux5u_CDNS_7823067815784

* +++++++++++++++++++++++++++++++++++++++++++++++++++++++++ *
* Sub cell: MASCO__A12                                      *
* +++++++++++++++++++++++++++++++++++++++++++++++++++++++++ *
.subckt MASCO__A12 1 2
*.DEVICECLIMB
** N=2 EP=2 FDC=0
X0 2 1 pnp5ux5u_CDNS_7823067815784 $T=1340 1340 0 0 $X=0 $Y=0
X1 2 1 pnp5ux5u_CDNS_7823067815784 $T=8380 1340 0 0 $X=7040 $Y=0
.ends MASCO__A12

* +++++++++++++++++++++++++++++++++++++++++++++++++++++++++ *
* Sub cell: MASCO__B13                                      *
* +++++++++++++++++++++++++++++++++++++++++++++++++++++++++ *
.subckt MASCO__B13 1 2 3
*.DEVICECLIMB
** N=3 EP=3 FDC=0
X0 1 2 MASCO__A12 $T=0 0 0 0 $X=0 $Y=0
X1 3 2 MASCO__A12 $T=0 7040 0 0 $X=0 $Y=7040
.ends MASCO__B13

* +++++++++++++++++++++++++++++++++++++++++++++++++++++++++ *
* Sub cell: MASCO__A14                                      *
* +++++++++++++++++++++++++++++++++++++++++++++++++++++++++ *
.subckt MASCO__A14 1 2 3
*.DEVICECLIMB
** N=3 EP=3 FDC=2
X0 2 3 1 MASCO__B13 $T=0 0 0 0 $X=0 $Y=0
X1 2 3 1 MASCO__B13 $T=14080 0 0 0 $X=14080 $Y=0
Q0 3 3 1 pnp5ux5u ae=2.5e-11 m=1 $X=7520 $Y=7520 $dt=4
Q1 3 3 1 pnp5ux5u ae=2.5e-11 m=1 $X=14560 $Y=7520 $dt=4
.ends MASCO__A14

* +++++++++++++++++++++++++++++++++++++++++++++++++++++++++ *
* Sub cell: MASCO__B15                                      *
* +++++++++++++++++++++++++++++++++++++++++++++++++++++++++ *
.subckt MASCO__B15 1 2 3
*.DEVICECLIMB
** N=3 EP=3 FDC=9
X0 3 1 2 MASCO__A14 $T=0 0 0 0 $X=0 $Y=0
X1 3 3 2 MASCO__A14 $T=0 14080 0 0 $X=0 $Y=14080
Q0 2 2 3 pnp5ux5u ae=2.5e-11 m=1 $X=7520 $Y=14560 $dt=4
Q1 2 2 3 pnp5ux5u ae=2.5e-11 m=1 $X=14560 $Y=14560 $dt=4
Q2 2 2 3 pnp5ux5u ae=2.5e-11 m=1 $X=21600 $Y=7520 $dt=4
Q3 2 2 3 pnp5ux5u ae=2.5e-11 m=1 $X=21600 $Y=14560 $dt=4
Q4 2 2 3 pnp5ux5u ae=2.5e-11 m=1 $X=21600 $Y=21600 $dt=4
.ends MASCO__B15

* +++++++++++++++++++++++++++++++++++++++++++++++++++++++++ *
* Sub cell: BG_PNP_array                                    *
* +++++++++++++++++++++++++++++++++++++++++++++++++++++++++ *
.subckt BG_PNP_array 1 2 3
** N=3 EP=3 FDC=266
X0 2 1 pnp5ux5u_CDNS_7823067815774 $T=129820 59315 0 0 $X=128480 $Y=57975
X1 2 3 pnp5ux5u_CDNS_7823067815783 $T=66460 52275 0 0 $X=65120 $Y=50935
X2 2 1 pnp5ux5u_CDNS_7823067815784 $T=59420 52275 0 0 $X=58080 $Y=50935
X3 2 2 pnp5ux5u_CDNS_7823067815784 $T=129820 2995 0 0 $X=128480 $Y=1655
X4 2 2 pnp5ux5u_CDNS_7823067815784 $T=129820 10035 0 0 $X=128480 $Y=8695
X5 2 1 pnp5ux5u_CDNS_7823067815784 $T=129820 17075 0 0 $X=128480 $Y=15735
X6 2 1 pnp5ux5u_CDNS_7823067815784 $T=129820 24115 0 0 $X=128480 $Y=22775
X7 2 1 pnp5ux5u_CDNS_7823067815784 $T=129820 31155 0 0 $X=128480 $Y=29815
X8 2 1 pnp5ux5u_CDNS_7823067815784 $T=129820 38195 0 0 $X=128480 $Y=36855
X9 2 1 pnp5ux5u_CDNS_7823067815784 $T=129820 45235 0 0 $X=128480 $Y=43895
X10 2 1 pnp5ux5u_CDNS_7823067815784 $T=129820 52275 0 0 $X=128480 $Y=50935
X11 2 1 pnp5ux5u_CDNS_7823067815784 $T=129820 66355 0 0 $X=128480 $Y=65015
X12 2 1 pnp5ux5u_CDNS_7823067815784 $T=129820 73395 0 0 $X=128480 $Y=72055
X13 2 1 pnp5ux5u_CDNS_7823067815784 $T=129820 80435 0 0 $X=128480 $Y=79095
X14 2 1 pnp5ux5u_CDNS_7823067815784 $T=129820 87475 0 0 $X=128480 $Y=86135
X15 2 1 pnp5ux5u_CDNS_7823067815784 $T=129820 94515 0 0 $X=128480 $Y=93175
X16 1 2 MASCO__A12 $T=58080 43895 0 0 $X=58080 $Y=43895
X17 2 2 2 MASCO__B13 $T=114400 1655 0 0 $X=114400 $Y=1655
X18 1 2 1 MASCO__B13 $T=114400 15735 0 0 $X=114400 $Y=15735
X19 1 2 1 MASCO__B13 $T=114400 29815 0 0 $X=114400 $Y=29815
X20 1 2 1 MASCO__B13 $T=114400 57975 0 0 $X=114400 $Y=57975
X21 1 2 1 MASCO__B13 $T=114400 72055 0 0 $X=114400 $Y=72055
X22 1 2 1 MASCO__B13 $T=114400 86135 0 0 $X=114400 $Y=86135
X23 1 1 2 MASCO__A14 $T=1760 86135 0 0 $X=1760 $Y=86135
X24 1 1 2 MASCO__A14 $T=29920 86135 0 0 $X=29920 $Y=86135
X25 1 1 2 MASCO__A14 $T=58080 29815 0 0 $X=58080 $Y=29815
X26 1 1 2 MASCO__A14 $T=58080 86135 0 0 $X=58080 $Y=86135
X27 1 1 2 MASCO__A14 $T=72160 43895 0 0 $X=72160 $Y=43895
X28 1 1 2 MASCO__A14 $T=86240 29815 0 0 $X=86240 $Y=29815
X29 1 1 2 MASCO__A14 $T=86240 86135 0 0 $X=86240 $Y=86135
X30 1 1 2 MASCO__A14 $T=100320 43895 0 0 $X=100320 $Y=43895
X31 1 2 1 MASCO__B15 $T=1760 1655 0 0 $X=1760 $Y=1655
X32 1 2 1 MASCO__B15 $T=1760 29815 0 0 $X=1760 $Y=29815
X33 1 2 1 MASCO__B15 $T=1760 57975 0 0 $X=1760 $Y=57975
X34 1 2 1 MASCO__B15 $T=29920 1655 0 0 $X=29920 $Y=1655
X35 1 2 1 MASCO__B15 $T=29920 29815 0 0 $X=29920 $Y=29815
X36 1 2 1 MASCO__B15 $T=29920 57975 0 0 $X=29920 $Y=57975
X37 1 2 1 MASCO__B15 $T=58080 1655 0 0 $X=58080 $Y=1655
X38 1 2 1 MASCO__B15 $T=58080 57975 0 0 $X=58080 $Y=57975
X39 2 2 1 MASCO__B15 $T=86240 1655 0 0 $X=86240 $Y=1655
X40 1 2 1 MASCO__B15 $T=86240 57975 0 0 $X=86240 $Y=57975
Q0 2 2 1 pnp5ux5u ae=2.5e-11 m=1 $X=2240 $Y=2135 $dt=4
Q1 2 2 1 pnp5ux5u ae=2.5e-11 m=1 $X=2240 $Y=9175 $dt=4
Q2 2 2 1 pnp5ux5u ae=2.5e-11 m=1 $X=2240 $Y=16215 $dt=4
Q3 2 2 1 pnp5ux5u ae=2.5e-11 m=1 $X=2240 $Y=23255 $dt=4
Q4 2 2 1 pnp5ux5u ae=2.5e-11 m=1 $X=2240 $Y=30295 $dt=4
Q5 2 2 1 pnp5ux5u ae=2.5e-11 m=1 $X=2240 $Y=37335 $dt=4
Q6 2 2 1 pnp5ux5u ae=2.5e-11 m=1 $X=2240 $Y=44375 $dt=4
Q7 2 2 1 pnp5ux5u ae=2.5e-11 m=1 $X=2240 $Y=51415 $dt=4
Q8 2 2 1 pnp5ux5u ae=2.5e-11 m=1 $X=2240 $Y=58455 $dt=4
Q9 2 2 1 pnp5ux5u ae=2.5e-11 m=1 $X=2240 $Y=65495 $dt=4
Q10 2 2 1 pnp5ux5u ae=2.5e-11 m=1 $X=2240 $Y=72535 $dt=4
Q11 2 2 1 pnp5ux5u ae=2.5e-11 m=1 $X=2240 $Y=79575 $dt=4
Q12 2 2 1 pnp5ux5u ae=2.5e-11 m=1 $X=2240 $Y=86615 $dt=4
Q13 2 2 1 pnp5ux5u ae=2.5e-11 m=1 $X=2240 $Y=93655 $dt=4
Q14 2 2 1 pnp5ux5u ae=2.5e-11 m=1 $X=9280 $Y=2135 $dt=4
Q15 2 2 1 pnp5ux5u ae=2.5e-11 m=1 $X=9280 $Y=30295 $dt=4
Q16 2 2 1 pnp5ux5u ae=2.5e-11 m=1 $X=9280 $Y=58455 $dt=4
Q17 2 2 1 pnp5ux5u ae=2.5e-11 m=1 $X=9280 $Y=86615 $dt=4
Q18 2 2 1 pnp5ux5u ae=2.5e-11 m=1 $X=16320 $Y=2135 $dt=4
Q19 2 2 1 pnp5ux5u ae=2.5e-11 m=1 $X=16320 $Y=30295 $dt=4
Q20 2 2 1 pnp5ux5u ae=2.5e-11 m=1 $X=16320 $Y=58455 $dt=4
Q21 2 2 1 pnp5ux5u ae=2.5e-11 m=1 $X=16320 $Y=86615 $dt=4
Q22 2 2 1 pnp5ux5u ae=2.5e-11 m=1 $X=23360 $Y=2135 $dt=4
Q23 2 2 1 pnp5ux5u ae=2.5e-11 m=1 $X=23360 $Y=30295 $dt=4
Q24 2 2 1 pnp5ux5u ae=2.5e-11 m=1 $X=23360 $Y=58455 $dt=4
Q25 2 2 1 pnp5ux5u ae=2.5e-11 m=1 $X=23360 $Y=86615 $dt=4
Q26 2 2 1 pnp5ux5u ae=2.5e-11 m=1 $X=23360 $Y=93655 $dt=4
Q27 2 2 1 pnp5ux5u ae=2.5e-11 m=1 $X=30400 $Y=2135 $dt=4
Q28 2 2 1 pnp5ux5u ae=2.5e-11 m=1 $X=30400 $Y=9175 $dt=4
Q29 2 2 1 pnp5ux5u ae=2.5e-11 m=1 $X=30400 $Y=16215 $dt=4
Q30 2 2 1 pnp5ux5u ae=2.5e-11 m=1 $X=30400 $Y=23255 $dt=4
Q31 2 2 1 pnp5ux5u ae=2.5e-11 m=1 $X=30400 $Y=30295 $dt=4
Q32 2 2 1 pnp5ux5u ae=2.5e-11 m=1 $X=30400 $Y=37335 $dt=4
Q33 2 2 1 pnp5ux5u ae=2.5e-11 m=1 $X=30400 $Y=44375 $dt=4
Q34 2 2 1 pnp5ux5u ae=2.5e-11 m=1 $X=30400 $Y=51415 $dt=4
Q35 2 2 1 pnp5ux5u ae=2.5e-11 m=1 $X=30400 $Y=58455 $dt=4
Q36 2 2 1 pnp5ux5u ae=2.5e-11 m=1 $X=30400 $Y=65495 $dt=4
Q37 2 2 1 pnp5ux5u ae=2.5e-11 m=1 $X=30400 $Y=72535 $dt=4
Q38 2 2 1 pnp5ux5u ae=2.5e-11 m=1 $X=30400 $Y=79575 $dt=4
Q39 2 2 1 pnp5ux5u ae=2.5e-11 m=1 $X=30400 $Y=86615 $dt=4
Q40 2 2 1 pnp5ux5u ae=2.5e-11 m=1 $X=30400 $Y=93655 $dt=4
Q41 2 2 1 pnp5ux5u ae=2.5e-11 m=1 $X=37440 $Y=2135 $dt=4
Q42 2 2 1 pnp5ux5u ae=2.5e-11 m=1 $X=37440 $Y=30295 $dt=4
Q43 2 2 1 pnp5ux5u ae=2.5e-11 m=1 $X=37440 $Y=58455 $dt=4
Q44 2 2 1 pnp5ux5u ae=2.5e-11 m=1 $X=37440 $Y=86615 $dt=4
Q45 2 2 1 pnp5ux5u ae=2.5e-11 m=1 $X=44480 $Y=2135 $dt=4
Q46 2 2 1 pnp5ux5u ae=2.5e-11 m=1 $X=44480 $Y=30295 $dt=4
Q47 2 2 1 pnp5ux5u ae=2.5e-11 m=1 $X=44480 $Y=58455 $dt=4
Q48 2 2 1 pnp5ux5u ae=2.5e-11 m=1 $X=44480 $Y=86615 $dt=4
Q49 2 2 1 pnp5ux5u ae=2.5e-11 m=1 $X=51520 $Y=2135 $dt=4
Q50 2 2 1 pnp5ux5u ae=2.5e-11 m=1 $X=51520 $Y=30295 $dt=4
Q51 2 2 1 pnp5ux5u ae=2.5e-11 m=1 $X=51520 $Y=58455 $dt=4
Q52 2 2 1 pnp5ux5u ae=2.5e-11 m=1 $X=51520 $Y=86615 $dt=4
Q53 2 2 1 pnp5ux5u ae=2.5e-11 m=1 $X=51520 $Y=93655 $dt=4
Q54 2 2 1 pnp5ux5u ae=2.5e-11 m=1 $X=58560 $Y=2135 $dt=4
Q55 2 2 1 pnp5ux5u ae=2.5e-11 m=1 $X=58560 $Y=9175 $dt=4
Q56 2 2 1 pnp5ux5u ae=2.5e-11 m=1 $X=58560 $Y=16215 $dt=4
Q57 2 2 1 pnp5ux5u ae=2.5e-11 m=1 $X=58560 $Y=23255 $dt=4
Q58 2 2 1 pnp5ux5u ae=2.5e-11 m=1 $X=58560 $Y=30295 $dt=4
Q59 2 2 1 pnp5ux5u ae=2.5e-11 m=1 $X=58560 $Y=37335 $dt=4
Q60 2 2 1 pnp5ux5u ae=2.5e-11 m=1 $X=58560 $Y=44375 $dt=4
Q61 2 2 1 pnp5ux5u ae=2.5e-11 m=1 $X=58560 $Y=51415 $dt=4
Q62 2 2 1 pnp5ux5u ae=2.5e-11 m=1 $X=58560 $Y=58455 $dt=4
Q63 2 2 1 pnp5ux5u ae=2.5e-11 m=1 $X=58560 $Y=65495 $dt=4
Q64 2 2 1 pnp5ux5u ae=2.5e-11 m=1 $X=58560 $Y=72535 $dt=4
Q65 2 2 1 pnp5ux5u ae=2.5e-11 m=1 $X=58560 $Y=79575 $dt=4
Q66 2 2 1 pnp5ux5u ae=2.5e-11 m=1 $X=58560 $Y=86615 $dt=4
Q67 2 2 1 pnp5ux5u ae=2.5e-11 m=1 $X=58560 $Y=93655 $dt=4
Q68 2 2 1 pnp5ux5u ae=2.5e-11 m=1 $X=65600 $Y=2135 $dt=4
Q69 2 2 1 pnp5ux5u ae=2.5e-11 m=1 $X=65600 $Y=30295 $dt=4
Q70 2 2 1 pnp5ux5u ae=2.5e-11 m=1 $X=65600 $Y=44375 $dt=4
Q71 2 2 1 pnp5ux5u ae=2.5e-11 m=1 $X=65600 $Y=58455 $dt=4
Q72 2 2 1 pnp5ux5u ae=2.5e-11 m=1 $X=65600 $Y=86615 $dt=4
Q73 2 2 1 pnp5ux5u ae=2.5e-11 m=1 $X=72640 $Y=2135 $dt=4
Q74 2 2 1 pnp5ux5u ae=2.5e-11 m=1 $X=72640 $Y=30295 $dt=4
Q75 2 2 1 pnp5ux5u ae=2.5e-11 m=1 $X=72640 $Y=44375 $dt=4
Q76 2 2 1 pnp5ux5u ae=2.5e-11 m=1 $X=72640 $Y=51415 $dt=4
Q77 2 2 1 pnp5ux5u ae=2.5e-11 m=1 $X=72640 $Y=58455 $dt=4
Q78 2 2 1 pnp5ux5u ae=2.5e-11 m=1 $X=72640 $Y=86615 $dt=4
Q79 2 2 1 pnp5ux5u ae=2.5e-11 m=1 $X=79680 $Y=2135 $dt=4
Q80 2 2 1 pnp5ux5u ae=2.5e-11 m=1 $X=79680 $Y=30295 $dt=4
Q81 2 2 1 pnp5ux5u ae=2.5e-11 m=1 $X=79680 $Y=37335 $dt=4
Q82 2 2 1 pnp5ux5u ae=2.5e-11 m=1 $X=79680 $Y=44375 $dt=4
Q83 2 2 1 pnp5ux5u ae=2.5e-11 m=1 $X=79680 $Y=58455 $dt=4
Q84 2 2 1 pnp5ux5u ae=2.5e-11 m=1 $X=79680 $Y=86615 $dt=4
Q85 2 2 1 pnp5ux5u ae=2.5e-11 m=1 $X=79680 $Y=93655 $dt=4
Q86 2 2 2 pnp5ux5u ae=2.5e-11 m=1 $X=86720 $Y=2135 $dt=4
Q87 2 2 1 pnp5ux5u ae=2.5e-11 m=1 $X=86720 $Y=9175 $dt=4
Q88 2 2 1 pnp5ux5u ae=2.5e-11 m=1 $X=86720 $Y=16215 $dt=4
Q89 2 2 1 pnp5ux5u ae=2.5e-11 m=1 $X=86720 $Y=23255 $dt=4
Q90 2 2 1 pnp5ux5u ae=2.5e-11 m=1 $X=86720 $Y=30295 $dt=4
Q91 2 2 1 pnp5ux5u ae=2.5e-11 m=1 $X=86720 $Y=37335 $dt=4
Q92 2 2 1 pnp5ux5u ae=2.5e-11 m=1 $X=86720 $Y=44375 $dt=4
Q93 2 2 1 pnp5ux5u ae=2.5e-11 m=1 $X=86720 $Y=58455 $dt=4
Q94 2 2 1 pnp5ux5u ae=2.5e-11 m=1 $X=86720 $Y=65495 $dt=4
Q95 2 2 1 pnp5ux5u ae=2.5e-11 m=1 $X=86720 $Y=72535 $dt=4
Q96 2 2 1 pnp5ux5u ae=2.5e-11 m=1 $X=86720 $Y=79575 $dt=4
Q97 2 2 1 pnp5ux5u ae=2.5e-11 m=1 $X=86720 $Y=86615 $dt=4
Q98 2 2 1 pnp5ux5u ae=2.5e-11 m=1 $X=86720 $Y=93655 $dt=4
Q99 2 2 2 pnp5ux5u ae=2.5e-11 m=1 $X=93760 $Y=2135 $dt=4
Q100 2 2 1 pnp5ux5u ae=2.5e-11 m=1 $X=93760 $Y=30295 $dt=4
Q101 2 2 1 pnp5ux5u ae=2.5e-11 m=1 $X=93760 $Y=44375 $dt=4
Q102 2 2 1 pnp5ux5u ae=2.5e-11 m=1 $X=93760 $Y=51415 $dt=4
Q103 2 2 1 pnp5ux5u ae=2.5e-11 m=1 $X=93760 $Y=58455 $dt=4
Q104 2 2 1 pnp5ux5u ae=2.5e-11 m=1 $X=93760 $Y=86615 $dt=4
Q105 2 2 2 pnp5ux5u ae=2.5e-11 m=1 $X=100800 $Y=2135 $dt=4
Q106 2 2 1 pnp5ux5u ae=2.5e-11 m=1 $X=100800 $Y=30295 $dt=4
Q107 2 2 1 pnp5ux5u ae=2.5e-11 m=1 $X=100800 $Y=44375 $dt=4
Q108 2 2 1 pnp5ux5u ae=2.5e-11 m=1 $X=100800 $Y=51415 $dt=4
Q109 2 2 1 pnp5ux5u ae=2.5e-11 m=1 $X=100800 $Y=58455 $dt=4
Q110 2 2 1 pnp5ux5u ae=2.5e-11 m=1 $X=100800 $Y=86615 $dt=4
Q111 2 2 2 pnp5ux5u ae=2.5e-11 m=1 $X=107840 $Y=2135 $dt=4
Q112 2 2 1 pnp5ux5u ae=2.5e-11 m=1 $X=107840 $Y=30295 $dt=4
Q113 2 2 1 pnp5ux5u ae=2.5e-11 m=1 $X=107840 $Y=37335 $dt=4
Q114 2 2 1 pnp5ux5u ae=2.5e-11 m=1 $X=107840 $Y=44375 $dt=4
Q115 2 2 1 pnp5ux5u ae=2.5e-11 m=1 $X=107840 $Y=58455 $dt=4
Q116 2 2 1 pnp5ux5u ae=2.5e-11 m=1 $X=107840 $Y=86615 $dt=4
Q117 2 2 1 pnp5ux5u ae=2.5e-11 m=1 $X=107840 $Y=93655 $dt=4
Q118 2 2 2 pnp5ux5u ae=2.5e-11 m=1 $X=114880 $Y=2135 $dt=4
Q119 2 2 2 pnp5ux5u ae=2.5e-11 m=1 $X=114880 $Y=9175 $dt=4
Q120 2 2 1 pnp5ux5u ae=2.5e-11 m=1 $X=114880 $Y=16215 $dt=4
Q121 2 2 1 pnp5ux5u ae=2.5e-11 m=1 $X=114880 $Y=23255 $dt=4
Q122 2 2 1 pnp5ux5u ae=2.5e-11 m=1 $X=114880 $Y=30295 $dt=4
Q123 2 2 1 pnp5ux5u ae=2.5e-11 m=1 $X=114880 $Y=37335 $dt=4
Q124 2 2 1 pnp5ux5u ae=2.5e-11 m=1 $X=114880 $Y=44375 $dt=4
Q125 2 2 1 pnp5ux5u ae=2.5e-11 m=1 $X=114880 $Y=58455 $dt=4
Q126 2 2 1 pnp5ux5u ae=2.5e-11 m=1 $X=114880 $Y=65495 $dt=4
Q127 2 2 1 pnp5ux5u ae=2.5e-11 m=1 $X=114880 $Y=72535 $dt=4
Q128 2 2 1 pnp5ux5u ae=2.5e-11 m=1 $X=114880 $Y=79575 $dt=4
Q129 2 2 1 pnp5ux5u ae=2.5e-11 m=1 $X=114880 $Y=86615 $dt=4
Q130 2 2 1 pnp5ux5u ae=2.5e-11 m=1 $X=114880 $Y=93655 $dt=4
Q131 2 2 2 pnp5ux5u ae=2.5e-11 m=1 $X=121920 $Y=2135 $dt=4
Q132 2 2 2 pnp5ux5u ae=2.5e-11 m=1 $X=121920 $Y=9175 $dt=4
Q133 2 2 1 pnp5ux5u ae=2.5e-11 m=1 $X=121920 $Y=16215 $dt=4
Q134 2 2 1 pnp5ux5u ae=2.5e-11 m=1 $X=121920 $Y=23255 $dt=4
Q135 2 2 1 pnp5ux5u ae=2.5e-11 m=1 $X=121920 $Y=30295 $dt=4
Q136 2 2 1 pnp5ux5u ae=2.5e-11 m=1 $X=121920 $Y=37335 $dt=4
Q137 2 2 1 pnp5ux5u ae=2.5e-11 m=1 $X=121920 $Y=44375 $dt=4
Q138 2 2 1 pnp5ux5u ae=2.5e-11 m=1 $X=121920 $Y=51415 $dt=4
Q139 2 2 1 pnp5ux5u ae=2.5e-11 m=1 $X=121920 $Y=58455 $dt=4
Q140 2 2 1 pnp5ux5u ae=2.5e-11 m=1 $X=121920 $Y=65495 $dt=4
Q141 2 2 1 pnp5ux5u ae=2.5e-11 m=1 $X=121920 $Y=72535 $dt=4
Q142 2 2 1 pnp5ux5u ae=2.5e-11 m=1 $X=121920 $Y=79575 $dt=4
Q143 2 2 1 pnp5ux5u ae=2.5e-11 m=1 $X=121920 $Y=86615 $dt=4
Q144 2 2 1 pnp5ux5u ae=2.5e-11 m=1 $X=121920 $Y=93655 $dt=4
Q145 2 2 2 pnp5ux5u ae=2.5e-11 m=1 $X=128960 $Y=2135 $dt=4
Q146 2 2 2 pnp5ux5u ae=2.5e-11 m=1 $X=128960 $Y=9175 $dt=4
Q147 2 2 1 pnp5ux5u ae=2.5e-11 m=1 $X=128960 $Y=16215 $dt=4
Q148 2 2 1 pnp5ux5u ae=2.5e-11 m=1 $X=128960 $Y=23255 $dt=4
Q149 2 2 1 pnp5ux5u ae=2.5e-11 m=1 $X=128960 $Y=30295 $dt=4
Q150 2 2 1 pnp5ux5u ae=2.5e-11 m=1 $X=128960 $Y=37335 $dt=4
Q151 2 2 1 pnp5ux5u ae=2.5e-11 m=1 $X=128960 $Y=44375 $dt=4
Q152 2 2 1 pnp5ux5u ae=2.5e-11 m=1 $X=128960 $Y=51415 $dt=4
Q153 2 2 1 pnp5ux5u ae=2.5e-11 m=1 $X=128960 $Y=58455 $dt=4
Q154 2 2 1 pnp5ux5u ae=2.5e-11 m=1 $X=128960 $Y=65495 $dt=4
Q155 2 2 1 pnp5ux5u ae=2.5e-11 m=1 $X=128960 $Y=72535 $dt=4
Q156 2 2 1 pnp5ux5u ae=2.5e-11 m=1 $X=128960 $Y=79575 $dt=4
Q157 2 2 1 pnp5ux5u ae=2.5e-11 m=1 $X=128960 $Y=86615 $dt=4
Q158 2 2 1 pnp5ux5u ae=2.5e-11 m=1 $X=128960 $Y=93655 $dt=4
.ends BG_PNP_array

* +++++++++++++++++++++++++++++++++++++++++++++++++++++++++ *
* Sub cell: pmos1v2hvt_4_CDNS_7823067815785                 *
* +++++++++++++++++++++++++++++++++++++++++++++++++++++++++ *
.subckt pmos1v2hvt_4_CDNS_7823067815785 1 2
** N=2 EP=2 FDC=1
X0 1 AbutContact_CDNS_7823067815742 $T=-330 -560 0 0 $X=-520 $Y=-620
X1 1 2 Contact_CDNS_7823067815759 $T=-245 130 0 0 $X=-245 $Y=0
X2 1 2 Contact_CDNS_7823067815759 $T=1095 130 0 0 $X=1095 $Y=0
X3 1 Contact_CDNS_7823067815761 $T=-275 90 0 0 $X=-275 $Y=0
X4 1 Contact_CDNS_7823067815761 $T=1065 90 0 0 $X=1065 $Y=0
M0 1 1 1 1 pmos1v2hvt L=1e-06 W=4e-05 AD=1.2e-11 AS=1.2e-11 PD=4.06e-05 PS=4.06e-05 m=1 $X=0 $Y=0 $dt=2
.ends pmos1v2hvt_4_CDNS_7823067815785

* +++++++++++++++++++++++++++++++++++++++++++++++++++++++++ *
* Sub cell: Contact_CDNS_7823067815770                      *
* +++++++++++++++++++++++++++++++++++++++++++++++++++++++++ *
.subckt Contact_CDNS_7823067815770 1 2
** N=2 EP=2 FDC=0
.ends Contact_CDNS_7823067815770

* +++++++++++++++++++++++++++++++++++++++++++++++++++++++++ *
* Sub cell: Contact_CDNS_7823067815772                      *
* +++++++++++++++++++++++++++++++++++++++++++++++++++++++++ *
.subckt Contact_CDNS_7823067815772 1
** N=1 EP=1 FDC=0
.ends Contact_CDNS_7823067815772

* +++++++++++++++++++++++++++++++++++++++++++++++++++++++++ *
* Sub cell: AbutContact_CDNS_7823067815773                  *
* +++++++++++++++++++++++++++++++++++++++++++++++++++++++++ *
.subckt AbutContact_CDNS_7823067815773 1
** N=1 EP=1 FDC=0
.ends AbutContact_CDNS_7823067815773

* +++++++++++++++++++++++++++++++++++++++++++++++++++++++++ *
* Sub cell: nmos1v2hvt_4_CDNS_7823067815769                 *
* +++++++++++++++++++++++++++++++++++++++++++++++++++++++++ *
.subckt nmos1v2hvt_4_CDNS_7823067815769 1 2 3 4
** N=4 EP=4 FDC=1
X0 1 4 Contact_CDNS_7823067815770 $T=-245 180 0 0 $X=-245 $Y=55
X1 2 4 Contact_CDNS_7823067815770 $T=2095 180 0 0 $X=2095 $Y=55
X2 1 Contact_CDNS_7823067815772 $T=-275 65 0 0 $X=-275 $Y=0
X3 2 Contact_CDNS_7823067815772 $T=2065 65 0 0 $X=2065 $Y=0
X4 4 AbutContact_CDNS_7823067815773 $T=-430 -560 0 0 $X=-520 $Y=-620
M0 2 3 1 4 nmos1v2hvt L=2e-06 W=2e-05 AD=6e-12 AS=6e-12 PD=2.06e-05 PS=2.06e-05 m=1 $X=0 $Y=0 $dt=1
.ends nmos1v2hvt_4_CDNS_7823067815769

* +++++++++++++++++++++++++++++++++++++++++++++++++++++++++ *
* Sub cell: MASCO__B6                                       *
* +++++++++++++++++++++++++++++++++++++++++++++++++++++++++ *
.subckt MASCO__B6 1 2 3 4 5 6 7
** N=7 EP=7 FDC=2
X0 7 6 2 3 nmos1v2hvt_4_CDNS_7823067815769 $T=20400 620 0 90 $X=0 $Y=0
X1 5 4 1 3 nmos1v2hvt_4_CDNS_7823067815769 $T=20400 3860 0 90 $X=0 $Y=3240
.ends MASCO__B6

* +++++++++++++++++++++++++++++++++++++++++++++++++++++++++ *
* Sub cell: MASCO__B9                                       *
* +++++++++++++++++++++++++++++++++++++++++++++++++++++++++ *
.subckt MASCO__B9 1 2 3 4 5 6 7 8 9 10
+ 11 12
** N=12 EP=12 FDC=4
X0 3 4 5 8 7 11 12 MASCO__B6 $T=0 0 0 0 $X=0 $Y=0
X1 1 2 5 9 10 6 7 MASCO__B6 $T=0 6480 0 0 $X=0 $Y=6480
.ends MASCO__B9

* +++++++++++++++++++++++++++++++++++++++++++++++++++++++++ *
* Sub cell: MASCO__B7                                       *
* +++++++++++++++++++++++++++++++++++++++++++++++++++++++++ *
.subckt MASCO__B7 1 2 3 4 5 6 7
** N=7 EP=7 FDC=2
X0 7 6 3 1 nmos1v2hvt_4_CDNS_7823067815769 $T=720 620 1 90 $X=0 $Y=0
X1 5 4 2 1 nmos1v2hvt_4_CDNS_7823067815769 $T=720 3860 1 90 $X=0 $Y=3240
.ends MASCO__B7

* +++++++++++++++++++++++++++++++++++++++++++++++++++++++++ *
* Sub cell: MASCO__B10                                      *
* +++++++++++++++++++++++++++++++++++++++++++++++++++++++++ *
.subckt MASCO__B10 1 2 3 4 5 6 7 8 9 10
+ 11 12
** N=12 EP=12 FDC=4
X0 1 5 3 8 7 12 11 MASCO__B7 $T=0 0 0 0 $X=0 $Y=0
X1 1 2 4 9 10 6 7 MASCO__B7 $T=0 6480 0 0 $X=0 $Y=6480
.ends MASCO__B10

* +++++++++++++++++++++++++++++++++++++++++++++++++++++++++ *
* Sub cell: pmos1v2hvt_4_CDNS_7823067815758                 *
* +++++++++++++++++++++++++++++++++++++++++++++++++++++++++ *
.subckt pmos1v2hvt_4_CDNS_7823067815758 1 2 3 4 5
** N=5 EP=5 FDC=1
X0 1 Contact_CDNS_782306781573 $T=2620 40100 0 0 $X=2500 $Y=40100
X1 4 5 AbutContact_CDNS_782306781574 $T=-330 -560 0 0 $X=-520 $Y=-620
X2 2 5 Contact_CDNS_7823067815759 $T=-245 130 0 0 $X=-245 $Y=0
X3 3 5 Contact_CDNS_7823067815759 $T=10095 130 0 0 $X=10095 $Y=0
M0 3 1 2 4 pmos1v2hvt L=1e-05 W=4e-05 AD=1.2e-11 AS=1.2e-11 PD=4.06e-05 PS=4.06e-05 m=1 $X=0 $Y=0 $dt=2
.ends pmos1v2hvt_4_CDNS_7823067815758

* +++++++++++++++++++++++++++++++++++++++++++++++++++++++++ *
* Sub cell: MASCO__B5                                       *
* +++++++++++++++++++++++++++++++++++++++++++++++++++++++++ *
.subckt MASCO__B5 1 2 3 4 5 6
** N=6 EP=6 FDC=2
X0 4 2 1 3 6 pmos1v2hvt_4_CDNS_7823067815758 $T=720 10620 0 270 $X=0 $Y=0
X1 4 3 2 3 6 pmos1v2hvt_4_CDNS_7823067815758 $T=720 21860 0 270 $X=0 $Y=11240
.ends MASCO__B5

* +++++++++++++++++++++++++++++++++++++++++++++++++++++++++ *
* Sub cell: MASCO__B8                                       *
* +++++++++++++++++++++++++++++++++++++++++++++++++++++++++ *
.subckt MASCO__B8 1 2 3 4 5 6 7 8
** N=8 EP=8 FDC=4
X0 1 5 3 6 6 8 MASCO__B5 $T=0 0 0 0 $X=0 $Y=0
X1 2 4 3 6 7 8 MASCO__B5 $T=0 22480 0 0 $X=0 $Y=22480
.ends MASCO__B8

* +++++++++++++++++++++++++++++++++++++++++++++++++++++++++ *
* Sub cell: MASCO__B11                                      *
* +++++++++++++++++++++++++++++++++++++++++++++++++++++++++ *
.subckt MASCO__B11 1 2 3 4 5 6 7 8 9 10
+ 11 12
** N=12 EP=12 FDC=8
X0 2 1 5 8 9 10 10 12 MASCO__B8 $T=0 0 0 0 $X=0 $Y=0
X1 4 3 5 6 7 11 5 12 MASCO__B8 $T=0 44960 0 0 $X=0 $Y=44960
.ends MASCO__B11

* +++++++++++++++++++++++++++++++++++++++++++++++++++++++++ *
* Sub cell: BG_TRIM_4_fL                                    *
* +++++++++++++++++++++++++++++++++++++++++++++++++++++++++ *
.subckt BG_TRIM_4_fL 16 9 19 44 55 56 57 58 59 60
+ 61 62 47 48 49 50 51 52 53 54
+ 46 45
** N=100 EP=22 FDC=886
X0 1 M2_M3_CDNS_782306781570 $T=12335 26875 0 0 $X=11810 $Y=26525
X1 1 M2_M3_CDNS_782306781570 $T=21075 110690 0 0 $X=20550 $Y=110340
X2 1 M2_M3_CDNS_782306781570 $T=29815 26875 0 0 $X=29290 $Y=26525
X3 1 M2_M3_CDNS_782306781570 $T=38555 110690 0 0 $X=38030 $Y=110340
X4 2 M2_M3_CDNS_782306781570 $T=42870 5010 0 0 $X=42345 $Y=4660
X5 1 M2_M3_CDNS_782306781570 $T=47295 26875 0 0 $X=46770 $Y=26525
X6 2 M2_M3_CDNS_782306781570 $T=48110 16650 0 0 $X=47585 $Y=16300
X7 1 M2_M3_CDNS_782306781570 $T=56035 110690 0 0 $X=55510 $Y=110340
X8 2 M2_M3_CDNS_782306781570 $T=58590 5010 0 0 $X=58065 $Y=4660
X9 2 M2_M3_CDNS_782306781570 $T=63830 16650 0 0 $X=63305 $Y=16300
X10 1 M2_M3_CDNS_782306781570 $T=64775 26875 0 0 $X=64250 $Y=26525
X11 1 M2_M3_CDNS_782306781570 $T=73515 110690 0 0 $X=72990 $Y=110340
X12 1 M2_M3_CDNS_782306781570 $T=81045 19490 0 90 $X=80695 $Y=18965
X13 1 M2_M3_CDNS_782306781570 $T=81045 25970 0 90 $X=80695 $Y=25445
X14 1 M2_M3_CDNS_782306781570 $T=81045 32450 0 90 $X=80695 $Y=31925
X15 1 M2_M3_CDNS_782306781570 $T=81045 38930 0 90 $X=80695 $Y=38405
X16 1 M2_M3_CDNS_782306781570 $T=81045 45410 0 90 $X=80695 $Y=44885
X17 1 M2_M3_CDNS_782306781570 $T=81045 51890 0 90 $X=80695 $Y=51365
X18 1 M2_M3_CDNS_782306781570 $T=81045 58370 0 90 $X=80695 $Y=57845
X19 1 M2_M3_CDNS_782306781570 $T=81045 64850 0 90 $X=80695 $Y=64325
X20 1 M2_M3_CDNS_782306781570 $T=81045 71330 0 90 $X=80695 $Y=70805
X21 1 M2_M3_CDNS_782306781570 $T=81045 77810 0 90 $X=80695 $Y=77285
X22 1 M2_M3_CDNS_782306781570 $T=81045 84290 0 90 $X=80695 $Y=83765
X23 1 M2_M3_CDNS_782306781570 $T=81045 90770 0 90 $X=80695 $Y=90245
X24 1 M2_M3_CDNS_782306781570 $T=81045 97250 0 90 $X=80695 $Y=96725
X25 1 M2_M3_CDNS_782306781570 $T=81045 103730 0 90 $X=80695 $Y=103205
X26 1 M2_M3_CDNS_782306781570 $T=81045 110210 0 90 $X=80695 $Y=109685
X27 3 M2_M3_CDNS_782306781570 $T=82245 16250 0 90 $X=81895 $Y=15725
X28 3 M2_M3_CDNS_782306781570 $T=82245 22730 0 90 $X=81895 $Y=22205
X29 3 M2_M3_CDNS_782306781570 $T=82245 29210 0 90 $X=81895 $Y=28685
X30 3 M2_M3_CDNS_782306781570 $T=82245 35690 0 90 $X=81895 $Y=35165
X31 3 M2_M3_CDNS_782306781570 $T=82245 42170 0 90 $X=81895 $Y=41645
X32 3 M2_M3_CDNS_782306781570 $T=82245 48650 0 90 $X=81895 $Y=48125
X33 3 M2_M3_CDNS_782306781570 $T=82245 55130 0 90 $X=81895 $Y=54605
X34 3 M2_M3_CDNS_782306781570 $T=82245 61610 0 90 $X=81895 $Y=61085
X35 3 M2_M3_CDNS_782306781570 $T=82245 74570 0 90 $X=81895 $Y=74045
X36 3 M2_M3_CDNS_782306781570 $T=82245 81050 0 90 $X=81895 $Y=80525
X37 3 M2_M3_CDNS_782306781570 $T=82245 87530 0 90 $X=81895 $Y=87005
X38 3 M2_M3_CDNS_782306781570 $T=82245 94010 0 90 $X=81895 $Y=93485
X39 3 M2_M3_CDNS_782306781570 $T=82245 100490 0 90 $X=81895 $Y=99965
X40 3 M2_M3_CDNS_782306781570 $T=82245 106970 0 90 $X=81895 $Y=106445
X41 2 M2_M3_CDNS_782306781570 $T=83445 14760 0 90 $X=83095 $Y=14235
X42 2 M2_M3_CDNS_782306781570 $T=83445 17995 0 90 $X=83095 $Y=17470
X43 2 M2_M3_CDNS_782306781570 $T=83445 21240 0 90 $X=83095 $Y=20715
X44 2 M2_M3_CDNS_782306781570 $T=83445 24480 0 90 $X=83095 $Y=23955
X45 2 M2_M3_CDNS_782306781570 $T=83445 27720 0 90 $X=83095 $Y=27195
X46 2 M2_M3_CDNS_782306781570 $T=83445 30960 0 90 $X=83095 $Y=30435
X47 2 M2_M3_CDNS_782306781570 $T=83445 34200 0 90 $X=83095 $Y=33675
X48 2 M2_M3_CDNS_782306781570 $T=83445 37440 0 90 $X=83095 $Y=36915
X49 2 M2_M3_CDNS_782306781570 $T=83445 40680 0 90 $X=83095 $Y=40155
X50 2 M2_M3_CDNS_782306781570 $T=83445 43920 0 90 $X=83095 $Y=43395
X51 2 M2_M3_CDNS_782306781570 $T=83445 47160 0 90 $X=83095 $Y=46635
X52 2 M2_M3_CDNS_782306781570 $T=83445 50400 0 90 $X=83095 $Y=49875
X53 2 M2_M3_CDNS_782306781570 $T=83445 53640 0 90 $X=83095 $Y=53115
X54 2 M2_M3_CDNS_782306781570 $T=83445 56880 0 90 $X=83095 $Y=56355
X55 2 M2_M3_CDNS_782306781570 $T=83445 60120 0 90 $X=83095 $Y=59595
X56 2 M2_M3_CDNS_782306781570 $T=83445 63360 0 90 $X=83095 $Y=62835
X57 2 M2_M3_CDNS_782306781570 $T=83445 66600 0 90 $X=83095 $Y=66075
X58 2 M2_M3_CDNS_782306781570 $T=83445 69840 0 90 $X=83095 $Y=69315
X59 2 M2_M3_CDNS_782306781570 $T=83445 73080 0 90 $X=83095 $Y=72555
X60 2 M2_M3_CDNS_782306781570 $T=83445 76320 0 90 $X=83095 $Y=75795
X61 2 M2_M3_CDNS_782306781570 $T=83445 79560 0 90 $X=83095 $Y=79035
X62 2 M2_M3_CDNS_782306781570 $T=83445 82800 0 90 $X=83095 $Y=82275
X63 2 M2_M3_CDNS_782306781570 $T=83445 86040 0 90 $X=83095 $Y=85515
X64 2 M2_M3_CDNS_782306781570 $T=83445 89280 0 90 $X=83095 $Y=88755
X65 2 M2_M3_CDNS_782306781570 $T=83445 92520 0 90 $X=83095 $Y=91995
X66 2 M2_M3_CDNS_782306781570 $T=83445 95760 0 90 $X=83095 $Y=95235
X67 2 M2_M3_CDNS_782306781570 $T=83445 99000 0 90 $X=83095 $Y=98475
X68 2 M2_M3_CDNS_782306781570 $T=83445 102240 0 90 $X=83095 $Y=101715
X69 2 M2_M3_CDNS_782306781570 $T=83445 105480 0 90 $X=83095 $Y=104955
X70 2 M2_M3_CDNS_782306781570 $T=83445 108720 0 90 $X=83095 $Y=108195
X71 2 M2_M3_CDNS_782306781570 $T=128085 14760 0 90 $X=127735 $Y=14235
X72 2 M2_M3_CDNS_782306781570 $T=128085 18000 0 90 $X=127735 $Y=17475
X73 2 M2_M3_CDNS_782306781570 $T=128085 21240 0 90 $X=127735 $Y=20715
X74 2 M2_M3_CDNS_782306781570 $T=128085 24480 0 90 $X=127735 $Y=23955
X75 2 M2_M3_CDNS_782306781570 $T=128085 27720 0 90 $X=127735 $Y=27195
X76 2 M2_M3_CDNS_782306781570 $T=128085 30960 0 90 $X=127735 $Y=30435
X77 2 M2_M3_CDNS_782306781570 $T=128085 34200 0 90 $X=127735 $Y=33675
X78 2 M2_M3_CDNS_782306781570 $T=128085 37440 0 90 $X=127735 $Y=36915
X79 2 M2_M3_CDNS_782306781570 $T=128085 40680 0 90 $X=127735 $Y=40155
X80 2 M2_M3_CDNS_782306781570 $T=128085 43920 0 90 $X=127735 $Y=43395
X81 2 M2_M3_CDNS_782306781570 $T=128085 47160 0 90 $X=127735 $Y=46635
X82 2 M2_M3_CDNS_782306781570 $T=128085 50400 0 90 $X=127735 $Y=49875
X83 2 M2_M3_CDNS_782306781570 $T=128085 56880 0 90 $X=127735 $Y=56355
X84 2 M2_M3_CDNS_782306781570 $T=128085 60120 0 90 $X=127735 $Y=59595
X85 2 M2_M3_CDNS_782306781570 $T=128085 66600 0 90 $X=127735 $Y=66075
X86 2 M2_M3_CDNS_782306781570 $T=128085 69840 0 90 $X=127735 $Y=69315
X87 2 M2_M3_CDNS_782306781570 $T=128085 76320 0 90 $X=127735 $Y=75795
X88 2 M2_M3_CDNS_782306781570 $T=128085 79560 0 90 $X=127735 $Y=79035
X89 2 M2_M3_CDNS_782306781570 $T=128085 86040 0 90 $X=127735 $Y=85515
X90 2 M2_M3_CDNS_782306781570 $T=128085 89280 0 90 $X=127735 $Y=88755
X91 2 M2_M3_CDNS_782306781570 $T=128085 99000 0 90 $X=127735 $Y=98475
X92 2 M2_M3_CDNS_782306781570 $T=128085 102240 0 90 $X=127735 $Y=101715
X93 2 M2_M3_CDNS_782306781570 $T=128085 105480 0 90 $X=127735 $Y=104955
X94 2 M2_M3_CDNS_782306781570 $T=128085 108720 0 90 $X=127735 $Y=108195
X95 1 M2_M3_CDNS_782306781570 $T=129285 16250 0 90 $X=128935 $Y=15725
X96 1 M2_M3_CDNS_782306781570 $T=129285 22730 0 90 $X=128935 $Y=22205
X97 1 M2_M3_CDNS_782306781570 $T=129285 29210 0 90 $X=128935 $Y=28685
X98 1 M2_M3_CDNS_782306781570 $T=129285 35690 0 90 $X=128935 $Y=35165
X99 1 M2_M3_CDNS_782306781570 $T=129285 42170 0 90 $X=128935 $Y=41645
X100 1 M2_M3_CDNS_782306781570 $T=129285 48650 0 90 $X=128935 $Y=48125
X101 1 M2_M3_CDNS_782306781570 $T=129285 55130 0 90 $X=128935 $Y=54605
X102 1 M2_M3_CDNS_782306781570 $T=129285 61610 0 90 $X=128935 $Y=61085
X103 1 M2_M3_CDNS_782306781570 $T=129285 68095 0 90 $X=128935 $Y=67570
X104 1 M2_M3_CDNS_782306781570 $T=129285 74570 0 90 $X=128935 $Y=74045
X105 1 M2_M3_CDNS_782306781570 $T=129285 81050 0 90 $X=128935 $Y=80525
X106 1 M2_M3_CDNS_782306781570 $T=129285 87530 0 90 $X=128935 $Y=87005
X107 1 M2_M3_CDNS_782306781570 $T=129285 94010 0 90 $X=128935 $Y=93485
X108 1 M2_M3_CDNS_782306781570 $T=129285 100490 0 90 $X=128935 $Y=99965
X109 1 M2_M3_CDNS_782306781570 $T=129285 106970 0 90 $X=128935 $Y=106445
X110 3 M2_M3_CDNS_782306781570 $T=130485 19490 0 90 $X=130135 $Y=18965
X111 3 M2_M3_CDNS_782306781570 $T=130485 25970 0 90 $X=130135 $Y=25445
X112 3 M2_M3_CDNS_782306781570 $T=130485 32450 0 90 $X=130135 $Y=31925
X113 3 M2_M3_CDNS_782306781570 $T=130485 38930 0 90 $X=130135 $Y=38405
X114 3 M2_M3_CDNS_782306781570 $T=130485 45410 0 90 $X=130135 $Y=44885
X115 3 M2_M3_CDNS_782306781570 $T=130485 51890 0 90 $X=130135 $Y=51365
X116 3 M2_M3_CDNS_782306781570 $T=130485 58370 0 90 $X=130135 $Y=57845
X117 3 M2_M3_CDNS_782306781570 $T=130485 64850 0 90 $X=130135 $Y=64325
X118 3 M2_M3_CDNS_782306781570 $T=130485 71330 0 90 $X=130135 $Y=70805
X119 3 M2_M3_CDNS_782306781570 $T=130485 77810 0 90 $X=130135 $Y=77285
X120 3 M2_M3_CDNS_782306781570 $T=130485 84290 0 90 $X=130135 $Y=83765
X121 3 M2_M3_CDNS_782306781570 $T=130485 90770 0 90 $X=130135 $Y=90245
X122 3 M2_M3_CDNS_782306781570 $T=130485 97250 0 90 $X=130135 $Y=96725
X123 3 M2_M3_CDNS_782306781570 $T=130485 103730 0 90 $X=130135 $Y=103205
X124 3 M2_M3_CDNS_782306781570 $T=130485 110210 0 90 $X=130135 $Y=109685
X125 4 M2_M3_CDNS_782306781570 $T=565930 109630 0 0 $X=565405 $Y=109280
X126 5 M2_M3_CDNS_782306781570 $T=566345 110970 0 0 $X=565820 $Y=110620
X127 4 M2_M3_CDNS_782306781570 $T=567610 109630 0 0 $X=567085 $Y=109280
X128 5 M2_M3_CDNS_782306781570 $T=568025 110970 0 0 $X=567500 $Y=110620
X129 4 M2_M3_CDNS_782306781570 $T=569290 109630 0 0 $X=568765 $Y=109280
X130 5 M2_M3_CDNS_782306781570 $T=569705 110970 0 0 $X=569180 $Y=110620
X131 4 M2_M3_CDNS_782306781570 $T=570970 109630 0 0 $X=570445 $Y=109280
X132 5 M2_M3_CDNS_782306781570 $T=571385 110970 0 0 $X=570860 $Y=110620
X133 4 M2_M3_CDNS_782306781570 $T=572650 109630 0 0 $X=572125 $Y=109280
X134 5 M2_M3_CDNS_782306781570 $T=573065 110970 0 0 $X=572540 $Y=110620
X135 4 M2_M3_CDNS_782306781570 $T=574330 109630 0 0 $X=573805 $Y=109280
X136 6 M2_M3_CDNS_782306781570 $T=578910 109630 0 0 $X=578385 $Y=109280
X137 7 M2_M3_CDNS_782306781570 $T=579325 110970 0 0 $X=578800 $Y=110620
X138 6 M2_M3_CDNS_782306781570 $T=580590 109630 0 0 $X=580065 $Y=109280
X139 7 M2_M3_CDNS_782306781570 $T=581005 110970 0 0 $X=580480 $Y=110620
X140 6 M2_M3_CDNS_782306781570 $T=582270 109630 0 0 $X=581745 $Y=109280
X141 7 M2_M3_CDNS_782306781570 $T=582685 110970 0 0 $X=582160 $Y=110620
X142 6 M2_M3_CDNS_782306781570 $T=583950 109630 0 0 $X=583425 $Y=109280
X143 7 M2_M3_CDNS_782306781570 $T=584365 110970 0 0 $X=583840 $Y=110620
X144 6 M2_M3_CDNS_782306781570 $T=585630 109630 0 0 $X=585105 $Y=109280
X145 7 M2_M3_CDNS_782306781570 $T=586045 110970 0 0 $X=585520 $Y=110620
X146 6 M2_M3_CDNS_782306781570 $T=587310 109630 0 0 $X=586785 $Y=109280
X147 3 M1_M2_CDNS_782306781571 $T=12060 68765 0 0 $X=11465 $Y=68660
X148 3 M1_M2_CDNS_782306781571 $T=20800 68765 0 0 $X=20205 $Y=68660
X149 3 M1_M2_CDNS_782306781571 $T=29540 68765 0 0 $X=28945 $Y=68660
X150 3 M1_M2_CDNS_782306781571 $T=38280 68765 0 0 $X=37685 $Y=68660
X151 3 M1_M2_CDNS_782306781571 $T=47020 68765 0 0 $X=46425 $Y=68660
X152 3 M1_M2_CDNS_782306781571 $T=55760 68765 0 0 $X=55165 $Y=68660
X153 3 M1_M2_CDNS_782306781571 $T=64500 68765 0 0 $X=63905 $Y=68660
X154 3 M1_M2_CDNS_782306781571 $T=73240 68765 0 0 $X=72645 $Y=68660
X155 3 M1_M2_CDNS_782306781572 $T=8840 68765 0 0 $X=6215 $Y=68660
X156 3 M1_M2_CDNS_782306781572 $T=17580 68765 0 0 $X=14955 $Y=68660
X157 3 M1_M2_CDNS_782306781572 $T=26320 68765 0 0 $X=23695 $Y=68660
X158 3 M1_M2_CDNS_782306781572 $T=35060 68765 0 0 $X=32435 $Y=68660
X159 3 M1_M2_CDNS_782306781572 $T=43800 68765 0 0 $X=41175 $Y=68660
X160 3 M1_M2_CDNS_782306781572 $T=52540 68765 0 0 $X=49915 $Y=68660
X161 3 M1_M2_CDNS_782306781572 $T=61280 68765 0 0 $X=58655 $Y=68660
X162 3 M1_M2_CDNS_782306781572 $T=70020 68765 0 0 $X=67395 $Y=68660
X163 3 M1_M2_CDNS_782306781573 $T=13910 68765 0 0 $X=12865 $Y=68660
X164 3 M1_M2_CDNS_782306781573 $T=22650 68765 0 0 $X=21605 $Y=68660
X165 3 M1_M2_CDNS_782306781573 $T=31390 68765 0 0 $X=30345 $Y=68660
X166 3 M1_M2_CDNS_782306781573 $T=40130 68765 0 0 $X=39085 $Y=68660
X167 3 M1_M2_CDNS_782306781573 $T=48870 68765 0 0 $X=47825 $Y=68660
X168 3 M1_M2_CDNS_782306781573 $T=57610 68765 0 0 $X=56565 $Y=68660
X169 3 M1_M2_CDNS_782306781573 $T=66350 68765 0 0 $X=65305 $Y=68660
X170 7 M1_M2_CDNS_782306781574 $T=105480 15150 0 90 $X=105355 $Y=14805
X171 7 M1_M2_CDNS_782306781574 $T=105480 19095 0 90 $X=105355 $Y=18750
X172 7 M1_M2_CDNS_782306781574 $T=105480 21630 0 90 $X=105355 $Y=21285
X173 7 M1_M2_CDNS_782306781574 $T=105480 25575 0 90 $X=105355 $Y=25230
X174 7 M1_M2_CDNS_782306781574 $T=105480 28110 0 90 $X=105355 $Y=27765
X175 7 M1_M2_CDNS_782306781574 $T=105480 32055 0 90 $X=105355 $Y=31710
X176 7 M1_M2_CDNS_782306781574 $T=105480 34590 0 90 $X=105355 $Y=34245
X177 7 M1_M2_CDNS_782306781574 $T=105480 38535 0 90 $X=105355 $Y=38190
X178 7 M1_M2_CDNS_782306781574 $T=105480 41070 0 90 $X=105355 $Y=40725
X179 7 M1_M2_CDNS_782306781574 $T=105480 45015 0 90 $X=105355 $Y=44670
X180 7 M1_M2_CDNS_782306781574 $T=105480 47550 0 90 $X=105355 $Y=47205
X181 7 M1_M2_CDNS_782306781574 $T=105480 51495 0 90 $X=105355 $Y=51150
X182 7 M1_M2_CDNS_782306781574 $T=105480 54030 0 90 $X=105355 $Y=53685
X183 7 M1_M2_CDNS_782306781574 $T=105480 57975 0 90 $X=105355 $Y=57630
X184 7 M1_M2_CDNS_782306781574 $T=105480 60510 0 90 $X=105355 $Y=60165
X185 7 M1_M2_CDNS_782306781574 $T=105480 64455 0 90 $X=105355 $Y=64110
X186 7 M1_M2_CDNS_782306781574 $T=105480 66990 0 90 $X=105355 $Y=66645
X187 7 M1_M2_CDNS_782306781574 $T=105480 70935 0 90 $X=105355 $Y=70590
X188 7 M1_M2_CDNS_782306781574 $T=105480 73470 0 90 $X=105355 $Y=73125
X189 7 M1_M2_CDNS_782306781574 $T=105480 77415 0 90 $X=105355 $Y=77070
X190 7 M1_M2_CDNS_782306781574 $T=105480 79950 0 90 $X=105355 $Y=79605
X191 7 M1_M2_CDNS_782306781574 $T=105480 83895 0 90 $X=105355 $Y=83550
X192 7 M1_M2_CDNS_782306781574 $T=105480 86430 0 90 $X=105355 $Y=86085
X193 7 M1_M2_CDNS_782306781574 $T=105480 90375 0 90 $X=105355 $Y=90030
X194 7 M1_M2_CDNS_782306781574 $T=105480 92910 0 90 $X=105355 $Y=92565
X195 7 M1_M2_CDNS_782306781574 $T=105480 96855 0 90 $X=105355 $Y=96510
X196 7 M1_M2_CDNS_782306781574 $T=105480 99390 0 90 $X=105355 $Y=99045
X197 7 M1_M2_CDNS_782306781574 $T=105480 103335 0 90 $X=105355 $Y=102990
X198 7 M1_M2_CDNS_782306781574 $T=105480 105870 0 90 $X=105355 $Y=105525
X199 7 M1_M2_CDNS_782306781574 $T=105480 109815 0 90 $X=105355 $Y=109470
X200 5 M1_M2_CDNS_782306781574 $T=106025 15860 0 90 $X=105900 $Y=15515
X201 5 M1_M2_CDNS_782306781574 $T=106025 19095 0 90 $X=105900 $Y=18750
X202 5 M1_M2_CDNS_782306781574 $T=106025 22340 0 90 $X=105900 $Y=21995
X203 5 M1_M2_CDNS_782306781574 $T=106025 25575 0 90 $X=105900 $Y=25230
X204 5 M1_M2_CDNS_782306781574 $T=106025 28820 0 90 $X=105900 $Y=28475
X205 5 M1_M2_CDNS_782306781574 $T=106025 32055 0 90 $X=105900 $Y=31710
X206 5 M1_M2_CDNS_782306781574 $T=106025 35300 0 90 $X=105900 $Y=34955
X207 5 M1_M2_CDNS_782306781574 $T=106025 38535 0 90 $X=105900 $Y=38190
X208 5 M1_M2_CDNS_782306781574 $T=106025 41780 0 90 $X=105900 $Y=41435
X209 5 M1_M2_CDNS_782306781574 $T=106025 45015 0 90 $X=105900 $Y=44670
X210 5 M1_M2_CDNS_782306781574 $T=106025 48260 0 90 $X=105900 $Y=47915
X211 5 M1_M2_CDNS_782306781574 $T=106025 51495 0 90 $X=105900 $Y=51150
X212 5 M1_M2_CDNS_782306781574 $T=106025 54740 0 90 $X=105900 $Y=54395
X213 5 M1_M2_CDNS_782306781574 $T=106025 57975 0 90 $X=105900 $Y=57630
X214 5 M1_M2_CDNS_782306781574 $T=106025 61220 0 90 $X=105900 $Y=60875
X215 5 M1_M2_CDNS_782306781574 $T=106025 64455 0 90 $X=105900 $Y=64110
X216 5 M1_M2_CDNS_782306781574 $T=106025 67700 0 90 $X=105900 $Y=67355
X217 5 M1_M2_CDNS_782306781574 $T=106025 70935 0 90 $X=105900 $Y=70590
X218 5 M1_M2_CDNS_782306781574 $T=106025 74180 0 90 $X=105900 $Y=73835
X219 5 M1_M2_CDNS_782306781574 $T=106025 77415 0 90 $X=105900 $Y=77070
X220 5 M1_M2_CDNS_782306781574 $T=106025 80660 0 90 $X=105900 $Y=80315
X221 5 M1_M2_CDNS_782306781574 $T=106025 83895 0 90 $X=105900 $Y=83550
X222 5 M1_M2_CDNS_782306781574 $T=106025 87140 0 90 $X=105900 $Y=86795
X223 5 M1_M2_CDNS_782306781574 $T=106025 90375 0 90 $X=105900 $Y=90030
X224 5 M1_M2_CDNS_782306781574 $T=106025 93620 0 90 $X=105900 $Y=93275
X225 5 M1_M2_CDNS_782306781574 $T=106025 96855 0 90 $X=105900 $Y=96510
X226 5 M1_M2_CDNS_782306781574 $T=106025 100100 0 90 $X=105900 $Y=99755
X227 5 M1_M2_CDNS_782306781574 $T=106025 103335 0 90 $X=105900 $Y=102990
X228 5 M1_M2_CDNS_782306781574 $T=106025 106580 0 90 $X=105900 $Y=106235
X229 5 M1_M2_CDNS_782306781574 $T=106025 109815 0 90 $X=105900 $Y=109470
X230 6 M1_M2_CDNS_782306781575 $T=208770 25815 0 0 $X=207270 $Y=25710
X231 6 M1_M2_CDNS_782306781575 $T=208770 93255 0 0 $X=207270 $Y=93150
X232 4 M1_M2_CDNS_782306781575 $T=212770 70775 0 0 $X=211270 $Y=70670
X233 8 M1_M2_CDNS_782306781575 $T=216770 48295 0 0 $X=215270 $Y=48190
X234 6 M1_M2_CDNS_782306781575 $T=254730 48295 0 0 $X=253230 $Y=48190
X235 4 M1_M2_CDNS_782306781575 $T=258730 25815 0 0 $X=257230 $Y=25710
X236 4 M1_M2_CDNS_782306781575 $T=258730 93255 0 0 $X=257230 $Y=93150
X237 8 M1_M2_CDNS_782306781575 $T=262730 70775 0 0 $X=261230 $Y=70670
X238 6 M1_M2_CDNS_782306781575 $T=301010 70775 0 0 $X=299510 $Y=70670
X239 4 M1_M2_CDNS_782306781575 $T=305010 48295 0 0 $X=303510 $Y=48190
X240 8 M1_M2_CDNS_782306781575 $T=309010 25815 0 0 $X=307510 $Y=25710
X241 8 M1_M2_CDNS_782306781575 $T=309010 93255 0 0 $X=307510 $Y=93150
X242 6 M1_M2_CDNS_782306781575 $T=347130 25815 0 0 $X=345630 $Y=25710
X243 6 M1_M2_CDNS_782306781575 $T=347130 93255 0 0 $X=345630 $Y=93150
X244 4 M1_M2_CDNS_782306781575 $T=351130 70775 0 0 $X=349630 $Y=70670
X245 8 M1_M2_CDNS_782306781575 $T=355130 48295 0 0 $X=353630 $Y=48190
X246 6 M1_M2_CDNS_782306781575 $T=393250 48295 0 0 $X=391750 $Y=48190
X247 4 M1_M2_CDNS_782306781575 $T=397250 25815 0 0 $X=395750 $Y=25710
X248 4 M1_M2_CDNS_782306781575 $T=397250 93255 0 0 $X=395750 $Y=93150
X249 8 M1_M2_CDNS_782306781575 $T=401250 70775 0 0 $X=399750 $Y=70670
X250 6 M1_M2_CDNS_782306781575 $T=439370 70775 0 0 $X=437870 $Y=70670
X251 4 M1_M2_CDNS_782306781575 $T=443370 48295 0 0 $X=441870 $Y=48190
X252 8 M1_M2_CDNS_782306781575 $T=447370 25815 0 0 $X=445870 $Y=25710
X253 8 M1_M2_CDNS_782306781575 $T=447370 93255 0 0 $X=445870 $Y=93150
X254 6 M1_M2_CDNS_782306781575 $T=485490 25815 0 0 $X=483990 $Y=25710
X255 6 M1_M2_CDNS_782306781575 $T=485490 93255 0 0 $X=483990 $Y=93150
X256 4 M1_M2_CDNS_782306781575 $T=489490 70775 0 0 $X=487990 $Y=70670
X257 8 M1_M2_CDNS_782306781575 $T=493490 48295 0 0 $X=491990 $Y=48190
X258 4 M1_M2_CDNS_782306781575 $T=535610 93255 0 0 $X=534110 $Y=93150
X259 8 M1_M2_CDNS_782306781575 $T=539610 70775 0 0 $X=538110 $Y=70670
X260 6 M2_M3_CDNS_782306781576 $T=208770 21915 0 0 $X=207270 $Y=20915
X261 4 M2_M3_CDNS_782306781576 $T=212770 19415 0 0 $X=211270 $Y=18415
X262 8 M2_M3_CDNS_782306781576 $T=216770 16915 0 0 $X=215270 $Y=15915
X263 6 M2_M3_CDNS_782306781576 $T=254730 21915 0 0 $X=253230 $Y=20915
X264 4 M2_M3_CDNS_782306781576 $T=258730 19415 0 0 $X=257230 $Y=18415
X265 8 M2_M3_CDNS_782306781576 $T=262730 16915 0 0 $X=261230 $Y=15915
X266 6 M2_M3_CDNS_782306781576 $T=301010 21915 0 0 $X=299510 $Y=20915
X267 4 M2_M3_CDNS_782306781576 $T=305010 19415 0 0 $X=303510 $Y=18415
X268 8 M2_M3_CDNS_782306781576 $T=309010 16915 0 0 $X=307510 $Y=15915
X269 6 M2_M3_CDNS_782306781576 $T=347130 21915 0 0 $X=345630 $Y=20915
X270 4 M2_M3_CDNS_782306781576 $T=351130 19415 0 0 $X=349630 $Y=18415
X271 8 M2_M3_CDNS_782306781576 $T=355130 16915 0 0 $X=353630 $Y=15915
X272 6 M2_M3_CDNS_782306781576 $T=393250 21915 0 0 $X=391750 $Y=20915
X273 4 M2_M3_CDNS_782306781576 $T=397250 19415 0 0 $X=395750 $Y=18415
X274 8 M2_M3_CDNS_782306781576 $T=401250 16915 0 0 $X=399750 $Y=15915
X275 6 M2_M3_CDNS_782306781576 $T=439370 21915 0 0 $X=437870 $Y=20915
X276 4 M2_M3_CDNS_782306781576 $T=443370 19415 0 0 $X=441870 $Y=18415
X277 8 M2_M3_CDNS_782306781576 $T=447370 16915 0 0 $X=445870 $Y=15915
X278 6 M2_M3_CDNS_782306781576 $T=485490 21915 0 0 $X=483990 $Y=20915
X279 4 M2_M3_CDNS_782306781576 $T=489490 19415 0 0 $X=487990 $Y=18415
X280 8 M2_M3_CDNS_782306781576 $T=493490 16915 0 0 $X=491990 $Y=15915
X281 6 M2_M3_CDNS_782306781576 $T=531610 21915 0 0 $X=530110 $Y=20915
X282 4 M2_M3_CDNS_782306781576 $T=535610 19415 0 0 $X=534110 $Y=18415
X283 8 M2_M3_CDNS_782306781576 $T=539610 16915 0 0 $X=538110 $Y=15915
X284 9 PG_M1_CDNS_782306781578 $T=22950 6080 0 0 $X=22670 $Y=5800
X285 10 PG_M1_CDNS_782306781578 $T=26165 6100 0 0 $X=25885 $Y=5820
X286 10 PG_M1_CDNS_782306781578 $T=29680 5910 0 0 $X=29400 $Y=5630
X287 11 PG_M1_CDNS_782306781578 $T=29880 11275 0 0 $X=29600 $Y=10995
X288 12 PG_M1_CDNS_782306781578 $T=170945 109230 0 0 $X=170665 $Y=108950
X289 13 PG_M1_CDNS_782306781578 $T=172685 109230 0 0 $X=172405 $Y=108950
X290 10 M1_M2_CDNS_782306781579 $T=23895 6100 0 0 $X=23790 $Y=5440
X291 1 M1_M2_CDNS_782306781579 $T=29805 25385 0 0 $X=29700 $Y=24725
X292 9 M1_M2_CDNS_7823067815710 $T=22900 6070 0 0 $X=22620 $Y=5760
X293 10 M1_M2_CDNS_7823067815710 $T=29680 5880 0 0 $X=29400 $Y=5570
X294 11 M1_M2_CDNS_7823067815710 $T=30395 8070 0 0 $X=30115 $Y=7760
X295 14 M1_M2_CDNS_7823067815710 $T=562890 12055 0 0 $X=562610 $Y=11745
X296 15 M1_M2_CDNS_7823067815711 $T=30830 9660 0 0 $X=30375 $Y=9175
X297 16 M1_M2_CDNS_7823067815711 $T=30840 12635 0 0 $X=30385 $Y=12150
X298 11 PG_M1_CDNS_7823067815712 $T=25945 23900 0 0 $X=25365 $Y=23620
X299 1 M1_M2_CDNS_7823067815716 $T=233000 110105 0 0 $X=232895 $Y=108045
X300 1 M1_M2_CDNS_7823067815716 $T=279120 110105 0 0 $X=279015 $Y=108045
X301 1 M1_M2_CDNS_7823067815716 $T=325240 110105 0 0 $X=325135 $Y=108045
X302 1 M1_M2_CDNS_7823067815716 $T=371360 110105 0 0 $X=371255 $Y=108045
X303 1 M1_M2_CDNS_7823067815716 $T=417480 110105 0 0 $X=417375 $Y=108045
X304 1 M1_M2_CDNS_7823067815716 $T=463600 110105 0 0 $X=463495 $Y=108045
X305 1 M1_M2_CDNS_7823067815716 $T=509720 110105 0 0 $X=509615 $Y=108045
X306 1 M1_M2_CDNS_7823067815716 $T=555840 110105 0 0 $X=555735 $Y=108045
X307 14 PG_M1_CDNS_7823067815717 $T=562890 11775 0 0 $X=562760 $Y=11495
X308 17 M2_M3_CDNS_7823067815718 $T=54785 19180 0 0 $X=53675 $Y=18830
X309 18 M2_M3_CDNS_7823067815718 $T=70505 17940 0 0 $X=69395 $Y=17590
X310 5 M2_M3_CDNS_7823067815721 $T=129085 117790 0 0 $X=128560 $Y=117635
X311 5 M2_M3_CDNS_7823067815721 $T=133405 114000 0 0 $X=132880 $Y=113845
X312 7 M2_M3_CDNS_7823067815721 $T=145425 118350 0 0 $X=144900 $Y=118195
X313 7 M2_M3_CDNS_7823067815721 $T=146715 114005 0 0 $X=146190 $Y=113850
X314 5 M1_M2_CDNS_7823067815722 $T=129085 117790 0 0 $X=128560 $Y=117635
X315 5 M1_M2_CDNS_7823067815722 $T=133405 114000 0 0 $X=132880 $Y=113845
X316 7 M1_M2_CDNS_7823067815722 $T=145425 118350 0 0 $X=144900 $Y=118195
X317 7 M1_M2_CDNS_7823067815722 $T=146715 114005 0 0 $X=146190 $Y=113850
X318 19 M1_M2_CDNS_7823067815723 $T=144700 17310 0 0 $X=143895 $Y=16300
X319 19 M1_M2_CDNS_7823067815723 $T=166165 17325 0 0 $X=165360 $Y=16315
X320 20 M1_M2_CDNS_7823067815724 $T=133025 46850 0 0 $X=132920 $Y=46365
X321 21 M1_M2_CDNS_7823067815724 $T=133025 48385 0 0 $X=132920 $Y=47900
X322 22 M1_M2_CDNS_7823067815724 $T=133035 43860 0 0 $X=132930 $Y=43375
X323 20 M1_M2_CDNS_7823067815724 $T=136150 31720 0 0 $X=136045 $Y=31235
X324 23 M1_M2_CDNS_7823067815724 $T=139635 43340 0 0 $X=139530 $Y=42855
X325 24 M1_M2_CDNS_7823067815724 $T=141835 43335 0 0 $X=141730 $Y=42850
X326 25 M1_M2_CDNS_7823067815724 $T=143780 47635 0 0 $X=143675 $Y=47150
X327 26 M1_M2_CDNS_7823067815724 $T=143810 44610 0 0 $X=143705 $Y=44125
X328 27 M1_M2_CDNS_7823067815724 $T=143810 49290 0 0 $X=143705 $Y=48805
X329 20 M1_M2_CDNS_7823067815724 $T=144035 31610 0 0 $X=143930 $Y=31125
X330 28 M1_M2_CDNS_7823067815724 $T=145700 36025 0 0 $X=145595 $Y=35540
X331 29 M1_M2_CDNS_7823067815724 $T=146340 43860 0 0 $X=146235 $Y=43375
X332 28 M1_M2_CDNS_7823067815724 $T=146340 46950 0 0 $X=146235 $Y=46465
X333 30 M1_M2_CDNS_7823067815724 $T=146340 48300 0 0 $X=146235 $Y=47815
X334 31 M1_M2_CDNS_7823067815724 $T=146350 45365 0 0 $X=146245 $Y=44880
X335 29 M1_M2_CDNS_7823067815724 $T=151965 31755 0 0 $X=151860 $Y=31270
X336 31 M1_M2_CDNS_7823067815724 $T=153130 33675 0 0 $X=153025 $Y=33190
X337 32 M1_M2_CDNS_7823067815724 $T=153695 34705 0 0 $X=153590 $Y=34220
X338 33 M1_M2_CDNS_7823067815724 $T=156060 32895 0 0 $X=155955 $Y=32410
X339 32 M1_M2_CDNS_7823067815724 $T=157115 46080 0 0 $X=157010 $Y=45595
X340 34 M1_M2_CDNS_7823067815724 $T=157115 49075 0 0 $X=157010 $Y=48590
X341 33 M1_M2_CDNS_7823067815724 $T=157120 44630 0 0 $X=157015 $Y=44145
X342 35 M1_M2_CDNS_7823067815724 $T=164025 72205 0 0 $X=163920 $Y=71720
X343 28 M1_M2_CDNS_7823067815724 $T=166890 35640 0 0 $X=166785 $Y=35155
X344 32 M1_M2_CDNS_7823067815724 $T=169090 34705 0 0 $X=168985 $Y=34220
X345 31 M1_M2_CDNS_7823067815724 $T=171290 33675 0 0 $X=171185 $Y=33190
X346 35 M1_M2_CDNS_7823067815724 $T=172175 72835 0 0 $X=172070 $Y=72350
X347 36 M1_M2_CDNS_7823067815724 $T=172180 80340 0 0 $X=172075 $Y=79855
X348 37 M1_M2_CDNS_7823067815724 $T=172185 87705 0 0 $X=172080 $Y=87220
X349 38 M1_M2_CDNS_7823067815724 $T=172190 95240 0 0 $X=172085 $Y=94755
X350 39 M1_M2_CDNS_7823067815724 $T=172800 83525 0 0 $X=172695 $Y=83040
X351 33 M1_M2_CDNS_7823067815724 $T=173490 32510 0 0 $X=173385 $Y=32025
X352 40 M1_M2_CDNS_7823067815724 $T=174110 80345 0 0 $X=174005 $Y=79860
X353 41 M1_M2_CDNS_7823067815724 $T=175025 91555 0 0 $X=174920 $Y=91070
X354 29 M1_M2_CDNS_7823067815724 $T=175690 31345 0 0 $X=175585 $Y=30860
X355 39 M1_M2_CDNS_7823067815724 $T=182965 84010 0 0 $X=182860 $Y=83525
X356 42 M1_M2_CDNS_7823067815724 $T=182975 99010 0 0 $X=182870 $Y=98525
X357 43 M1_M2_CDNS_7823067815725 $T=155910 50670 0 0 $X=155455 $Y=50535
X358 35 M1_M2_CDNS_7823067815725 $T=169960 72840 0 0 $X=169505 $Y=72705
X359 16 M2_M3_CDNS_7823067815727 $T=30840 12635 0 0 $X=30315 $Y=12090
X360 13 M2_M3_CDNS_7823067815727 $T=173750 107755 0 0 $X=173225 $Y=107210
X361 44 M2_M3_CDNS_7823067815728 $T=614655 10115 0 0 $X=614325 $Y=9765
X362 2 M2_M3_CDNS_7823067815732 $T=128105 53660 0 0 $X=127775 $Y=53115
X363 2 M2_M3_CDNS_7823067815732 $T=128105 63380 0 0 $X=127775 $Y=62835
X364 2 M2_M3_CDNS_7823067815732 $T=128105 73100 0 0 $X=127775 $Y=72555
X365 2 M2_M3_CDNS_7823067815732 $T=128105 82820 0 0 $X=127775 $Y=82275
X366 2 M2_M3_CDNS_7823067815732 $T=128105 92540 0 0 $X=127775 $Y=91995
X367 2 M2_M3_CDNS_7823067815732 $T=128105 95780 0 0 $X=127775 $Y=95235
X368 8 M2_M3_CDNS_7823067815732 $T=174005 109990 0 0 $X=173675 $Y=109445
X369 8 M2_M3_CDNS_7823067815732 $T=175685 109990 0 0 $X=175355 $Y=109445
X370 8 M2_M3_CDNS_7823067815732 $T=177365 109990 0 0 $X=177035 $Y=109445
X371 8 M2_M3_CDNS_7823067815732 $T=179055 109990 0 0 $X=178725 $Y=109445
X372 8 M2_M3_CDNS_7823067815732 $T=180725 109990 0 0 $X=180395 $Y=109445
X373 8 M2_M3_CDNS_7823067815732 $T=182405 109990 0 0 $X=182075 $Y=109445
X374 13 M2_M3_CDNS_7823067815732 $T=564510 112275 0 0 $X=564180 $Y=111730
X375 4 M1_M2_CDNS_7823067815734 $T=565930 109630 0 0 $X=565405 $Y=109280
X376 4 M1_M2_CDNS_7823067815734 $T=567610 109630 0 0 $X=567085 $Y=109280
X377 4 M1_M2_CDNS_7823067815734 $T=569290 109630 0 0 $X=568765 $Y=109280
X378 4 M1_M2_CDNS_7823067815734 $T=570970 109630 0 0 $X=570445 $Y=109280
X379 4 M1_M2_CDNS_7823067815734 $T=572650 109630 0 0 $X=572125 $Y=109280
X380 4 M1_M2_CDNS_7823067815734 $T=574330 109630 0 0 $X=573805 $Y=109280
X381 6 M1_M2_CDNS_7823067815734 $T=578910 109630 0 0 $X=578385 $Y=109280
X382 6 M1_M2_CDNS_7823067815734 $T=580590 109630 0 0 $X=580065 $Y=109280
X383 6 M1_M2_CDNS_7823067815734 $T=582270 109630 0 0 $X=581745 $Y=109280
X384 6 M1_M2_CDNS_7823067815734 $T=583950 109630 0 0 $X=583425 $Y=109280
X385 6 M1_M2_CDNS_7823067815734 $T=585630 109630 0 0 $X=585105 $Y=109280
X386 6 M1_M2_CDNS_7823067815734 $T=587310 109630 0 0 $X=586785 $Y=109280
X387 6 M2_M3_CDNS_7823067815735 $T=531610 107625 0 0 $X=530110 $Y=107080
X388 4 M2_M3_CDNS_7823067815735 $T=535610 109775 0 0 $X=534110 $Y=109230
X389 15 M1_M2_CDNS_7823067815737 $T=30435 4830 0 0 $X=30155 $Y=4345
X390 5 M1_M2_CDNS_7823067815737 $T=598160 104615 0 0 $X=597880 $Y=104130
X391 19 45 cmims_CDNS_782306781570 $T=96300 64190 0 90 $X=25800 $Y=63690
X392 19 45 cmims_CDNS_782306781570 $T=169300 64190 0 90 $X=98800 $Y=63690
X393 19 45 cmims_CDNS_782306781570 $T=242300 64190 0 90 $X=171800 $Y=63690
X394 19 45 cmims_CDNS_782306781570 $T=315300 64190 0 90 $X=244800 $Y=63690
X395 19 45 cmims_CDNS_782306781570 $T=388300 64190 0 90 $X=317800 $Y=63690
X396 19 45 cmims_CDNS_782306781570 $T=461300 64190 0 90 $X=390800 $Y=63690
X397 19 45 cmims_CDNS_782306781570 $T=534300 64190 0 90 $X=463800 $Y=63690
X398 19 45 cmims_CDNS_782306781570 $T=607300 64190 0 90 $X=536800 $Y=63690
X399 19 45 cmims_CDNS_782306781570 $T=680300 64190 0 90 $X=609800 $Y=63690
X400 19 45 cmims_CDNS_782306781570 $T=753300 64190 0 90 $X=682800 $Y=63690
X401 46 19 pmos1v2hvt_4_CDNS_782306781571 $T=185650 35985 0 270 $X=184930 $Y=25365
X402 46 19 pmos1v2hvt_4_CDNS_782306781571 $T=185650 47225 0 270 $X=184930 $Y=36605
X403 46 19 pmos1v2hvt_4_CDNS_782306781571 $T=185650 58465 0 270 $X=184930 $Y=47845
X404 46 19 pmos1v2hvt_4_CDNS_782306781571 $T=185650 69705 0 270 $X=184930 $Y=59085
X405 46 19 pmos1v2hvt_4_CDNS_782306781571 $T=185650 80945 0 270 $X=184930 $Y=70325
X406 46 19 pmos1v2hvt_4_CDNS_782306781571 $T=185650 92185 0 270 $X=184930 $Y=81565
X407 46 19 pmos1v2hvt_4_CDNS_782306781571 $T=185650 103425 0 270 $X=184930 $Y=92805
X408 46 19 pmos1v2hvt_4_CDNS_782306781571 $T=185650 114665 0 270 $X=184930 $Y=104045
X409 46 19 pmos1v2hvt_4_CDNS_782306781571 $T=561730 35985 0 270 $X=561010 $Y=25365
X410 46 19 pmos1v2hvt_4_CDNS_782306781571 $T=561730 47225 0 270 $X=561010 $Y=36605
X411 46 19 pmos1v2hvt_4_CDNS_782306781571 $T=561730 58465 0 270 $X=561010 $Y=47845
X412 46 19 pmos1v2hvt_4_CDNS_782306781571 $T=561730 69705 0 270 $X=561010 $Y=59085
X413 46 19 pmos1v2hvt_4_CDNS_782306781571 $T=561730 80945 0 270 $X=561010 $Y=70325
X414 46 19 pmos1v2hvt_4_CDNS_782306781571 $T=561730 92185 0 270 $X=561010 $Y=81565
X415 46 19 pmos1v2hvt_4_CDNS_782306781571 $T=561730 103425 0 270 $X=561010 $Y=92805
X416 46 19 pmos1v2hvt_4_CDNS_782306781571 $T=561730 114665 0 270 $X=561010 $Y=104045
X417 19 19 rnpolyh_CDNS_782306781575 $T=597160 94560 0 0 $X=596910 $Y=93820
X418 19 19 rnpolyh_CDNS_782306781575 $T=616660 94560 0 0 $X=616410 $Y=93820
X419 47 48 49 19 50 51 52 53 54 19
+ 27 21 25 20 24 23 26 22 mux8_1_fL $T=153320 17600 1 180 $X=133890 $Y=17600
X420 47 48 49 19 50 51 52 53 54 19
+ 34 30 43 28 32 31 33 29 mux8_1_fL $T=157605 17600 0 0 $X=157605 $Y=17600
X421 55 56 57 19 58 59 60 61 62 19
+ 42 38 41 37 39 36 40 35 mux8_1_fL $T=182115 52440 1 180 $X=162685 $Y=52440
X422 63 5 19 rnpolyh_CDNS_7823067815711 $T=597910 104560 1 0 $X=597660 $Y=93820
X423 46 10 9 19 pmos1v2hvt_4_CDNS_7823067815720 $T=23230 8885 1 0 $X=22610 $Y=6485
X424 46 11 10 19 pmos1v2hvt_4_CDNS_7823067815720 $T=26445 8885 1 0 $X=25825 $Y=6485
X425 19 15 13 nmos1v2hvt_4_CDNS_7823067815726 $T=49605 6220 0 0 $X=48985 $Y=5500
X426 19 15 17 nmos1v2hvt_4_CDNS_7823067815726 $T=49605 15440 1 0 $X=48985 $Y=11040
X427 19 15 18 nmos1v2hvt_4_CDNS_7823067815726 $T=65325 15440 1 0 $X=64705 $Y=11040
X428 19 19 10 9 nmos1v2hvt_4_CDNS_7823067815734 $T=23230 4315 0 0 $X=22610 $Y=3595
X429 19 19 11 10 nmos1v2hvt_4_CDNS_7823067815734 $T=26445 4315 0 0 $X=25825 $Y=3595
X430 19 19 15 10 nmos1v2hvt_4_CDNS_7823067815734 $T=29415 4315 0 0 $X=28795 $Y=3595
X431 15 19 16 11 nmos1v2hvt_4_CDNS_7823067815734 $T=31340 11030 0 90 $X=29940 $Y=10410
X432 11 46 18 19 10 45 14 44 BG_STARTUP_fL2 $T=560405 3770 0 0 $X=563405 $Y=4015
X433 1 17 19 14 nmos1v2hvt_4_CDNS_7823067815747 $T=562835 9315 0 0 $X=562215 $Y=8595
X434 19 45 35 40 19 36 39 37 41 38
+ 42 19 trim_res_bg_2_fL $T=184240 66870 0 90 $X=159530 $Y=66870
X435 19 5 27 21 25 20 24 23 26 22
+ 19 19 trim_res_bg_sl_fL $T=131760 116170 0 270 $X=131765 $Y=41335
X436 19 7 34 30 43 28 32 31 33 29
+ 19 19 trim_res_bg_sl_fL $T=145070 116170 0 270 $X=145075 $Y=41335
X437 46 1 11 19 pmos1v2hvt_4_CDNS_7823067815754 $T=24945 25160 1 0 $X=24325 $Y=24200
X438 46 12 46 19 pmos1v2hvt_4_CDNS_7823067815756 $T=170695 114690 1 0 $X=170075 $Y=109290
X439 12 13 46 19 pmos1v2hvt_4_CDNS_7823067815756 $T=172435 114690 1 0 $X=171815 $Y=109290
X440 46 1 3 19 pmos1v2hvt_4_CDNS_7823067815760 $T=5090 28105 0 0 $X=4470 $Y=27385
X441 46 3 3 19 pmos1v2hvt_4_CDNS_7823067815760 $T=5090 109425 1 0 $X=4470 $Y=69025
X442 46 3 3 19 pmos1v2hvt_4_CDNS_7823067815760 $T=13830 28105 0 0 $X=13210 $Y=27385
X443 46 1 3 19 pmos1v2hvt_4_CDNS_7823067815760 $T=13830 109425 1 0 $X=13210 $Y=69025
X444 46 1 3 19 pmos1v2hvt_4_CDNS_7823067815760 $T=22570 28105 0 0 $X=21950 $Y=27385
X445 46 3 3 19 pmos1v2hvt_4_CDNS_7823067815760 $T=22570 109425 1 0 $X=21950 $Y=69025
X446 46 3 3 19 pmos1v2hvt_4_CDNS_7823067815760 $T=31310 28105 0 0 $X=30690 $Y=27385
X447 46 1 3 19 pmos1v2hvt_4_CDNS_7823067815760 $T=31310 109425 1 0 $X=30690 $Y=69025
X448 46 1 3 19 pmos1v2hvt_4_CDNS_7823067815760 $T=40050 28105 0 0 $X=39430 $Y=27385
X449 46 3 3 19 pmos1v2hvt_4_CDNS_7823067815760 $T=40050 109425 1 0 $X=39430 $Y=69025
X450 46 3 3 19 pmos1v2hvt_4_CDNS_7823067815760 $T=48790 28105 0 0 $X=48170 $Y=27385
X451 46 1 3 19 pmos1v2hvt_4_CDNS_7823067815760 $T=48790 109425 1 0 $X=48170 $Y=69025
X452 46 1 3 19 pmos1v2hvt_4_CDNS_7823067815760 $T=57530 28105 0 0 $X=56910 $Y=27385
X453 46 3 3 19 pmos1v2hvt_4_CDNS_7823067815760 $T=57530 109425 1 0 $X=56910 $Y=69025
X454 46 3 3 19 pmos1v2hvt_4_CDNS_7823067815760 $T=66270 28105 0 0 $X=65650 $Y=27385
X455 46 1 3 19 pmos1v2hvt_4_CDNS_7823067815760 $T=66270 109425 1 0 $X=65650 $Y=69025
X456 46 8 45 13 19 pmos1v2hvt_4_CDNS_7823067815766 $T=174175 114690 1 0 $X=173555 $Y=110280
X457 46 4 5 13 19 pmos1v2hvt_4_CDNS_7823067815766 $T=573735 116200 0 180 $X=565055 $Y=111790
X458 46 6 7 13 19 pmos1v2hvt_4_CDNS_7823067815766 $T=586715 116200 0 180 $X=578035 $Y=111790
X459 63 19 7 BG_PNP_array $T=616950 5640 0 0 $X=618710 $Y=7295
X460 46 19 pmos1v2hvt_4_CDNS_7823067815785 $T=2850 28105 0 0 $X=2230 $Y=27385
X461 46 19 pmos1v2hvt_4_CDNS_7823067815785 $T=2850 109425 1 0 $X=2230 $Y=69025
X462 46 19 pmos1v2hvt_4_CDNS_7823067815785 $T=75010 28105 0 0 $X=74390 $Y=27385
X463 46 19 pmos1v2hvt_4_CDNS_7823067815785 $T=75010 109425 1 0 $X=74390 $Y=69025
X464 7 5 7 19 19 3 2 1 1 2
+ 19 19 MASCO__B9 $T=106475 10645 0 0 $X=106475 $Y=10645
X465 7 5 7 5 19 3 2 1 1 2
+ 3 2 MASCO__B9 $T=106475 23605 0 0 $X=106475 $Y=23605
X466 7 5 7 5 19 3 2 1 1 2
+ 3 2 MASCO__B9 $T=106475 36565 0 0 $X=106475 $Y=36565
X467 7 5 7 5 19 3 2 1 1 2
+ 3 2 MASCO__B9 $T=106475 49525 0 0 $X=106475 $Y=49525
X468 7 5 7 5 19 3 2 1 1 2
+ 3 2 MASCO__B9 $T=106475 62485 0 0 $X=106475 $Y=62485
X469 7 5 7 5 19 3 2 1 1 2
+ 3 2 MASCO__B9 $T=106475 75445 0 0 $X=106475 $Y=75445
X470 7 5 7 5 19 3 2 1 1 2
+ 3 2 MASCO__B9 $T=106475 88405 0 0 $X=106475 $Y=88405
X471 19 5 7 5 19 3 2 1 19 19
+ 3 2 MASCO__B9 $T=106475 101365 0 0 $X=106475 $Y=101365
X472 19 5 19 7 5 1 2 3 3 2
+ 19 19 MASCO__B10 $T=83935 10645 0 0 $X=83935 $Y=10645
X473 19 5 7 7 5 1 2 3 3 2
+ 2 1 MASCO__B10 $T=83935 23605 0 0 $X=83935 $Y=23605
X474 19 5 7 7 5 1 2 3 3 2
+ 2 1 MASCO__B10 $T=83935 36565 0 0 $X=83935 $Y=36565
X475 19 5 7 7 5 1 2 3 3 2
+ 2 1 MASCO__B10 $T=83935 49525 0 0 $X=83935 $Y=49525
X476 19 5 7 7 5 1 2 3 3 2
+ 2 1 MASCO__B10 $T=83935 62485 0 0 $X=83935 $Y=62485
X477 19 5 7 7 5 1 2 3 3 2
+ 2 1 MASCO__B10 $T=83935 75445 0 0 $X=83935 $Y=75445
X478 19 5 7 7 5 1 2 3 3 2
+ 2 1 MASCO__B10 $T=83935 88405 0 0 $X=83935 $Y=88405
X479 19 19 7 7 5 1 2 3 19 19
+ 2 1 MASCO__B10 $T=83935 101365 0 0 $X=83935 $Y=101365
X480 8 6 6 4 46 64 65 66 67 1
+ 1 19 MASCO__B11 $T=192050 25365 0 0 $X=192050 $Y=25365
X481 6 4 4 8 46 68 69 70 71 1
+ 1 19 MASCO__B11 $T=238170 25365 0 0 $X=238170 $Y=25365
X482 4 8 8 6 46 72 73 74 75 1
+ 1 19 MASCO__B11 $T=284290 25365 0 0 $X=284290 $Y=25365
X483 8 6 6 4 46 76 77 78 79 1
+ 1 19 MASCO__B11 $T=330410 25365 0 0 $X=330410 $Y=25365
X484 6 4 4 8 46 80 81 82 83 1
+ 1 19 MASCO__B11 $T=376530 25365 0 0 $X=376530 $Y=25365
X485 4 8 8 6 46 84 85 86 87 1
+ 1 19 MASCO__B11 $T=422650 25365 0 0 $X=422650 $Y=25365
X486 8 6 6 4 46 88 89 90 91 1
+ 1 19 MASCO__B11 $T=468770 25365 0 0 $X=468770 $Y=25365
X487 46 46 4 8 46 92 93 46 46 46
+ 1 19 MASCO__B11 $T=514890 25365 0 0 $X=514890 $Y=25365
M0 19 19 19 19 nmos1v2hvt L=4e-06 W=4e-06 AD=1.2e-12 AS=1.2e-12 PD=4.6e-06 PS=4.6e-06 m=1 $X=33885 $Y=6220 $dt=1
M1 19 19 19 19 nmos1v2hvt L=4e-06 W=4e-06 AD=1.2e-12 AS=1.2e-12 PD=4.6e-06 PS=4.6e-06 m=1 $X=33885 $Y=11440 $dt=1
M2 2 15 19 19 nmos1v2hvt L=4e-06 W=4e-06 AD=1.2e-12 AS=1.2e-12 PD=4.6e-06 PS=4.6e-06 m=1 $X=39125 $Y=6220 $dt=1
M3 15 15 19 19 nmos1v2hvt L=4e-06 W=4e-06 AD=1.2e-12 AS=1.2e-12 PD=4.6e-06 PS=4.6e-06 m=1 $X=39125 $Y=11440 $dt=1
M4 15 15 19 19 nmos1v2hvt L=4e-06 W=4e-06 AD=1.2e-12 AS=1.2e-12 PD=4.6e-06 PS=4.6e-06 m=1 $X=44365 $Y=6220 $dt=1
M5 2 15 19 19 nmos1v2hvt L=4e-06 W=4e-06 AD=1.2e-12 AS=1.2e-12 PD=4.6e-06 PS=4.6e-06 m=1 $X=44365 $Y=11440 $dt=1
M6 2 15 19 19 nmos1v2hvt L=4e-06 W=4e-06 AD=1.2e-12 AS=1.2e-12 PD=4.6e-06 PS=4.6e-06 m=1 $X=54845 $Y=6220 $dt=1
M7 15 15 19 19 nmos1v2hvt L=4e-06 W=4e-06 AD=1.2e-12 AS=1.2e-12 PD=4.6e-06 PS=4.6e-06 m=1 $X=54845 $Y=11440 $dt=1
M8 15 15 19 19 nmos1v2hvt L=4e-06 W=4e-06 AD=1.2e-12 AS=1.2e-12 PD=4.6e-06 PS=4.6e-06 m=1 $X=60085 $Y=6220 $dt=1
M9 2 15 19 19 nmos1v2hvt L=4e-06 W=4e-06 AD=1.2e-12 AS=1.2e-12 PD=4.6e-06 PS=4.6e-06 m=1 $X=60085 $Y=11440 $dt=1
M10 19 19 19 19 nmos1v2hvt L=4e-06 W=4e-06 AD=1.2e-12 AS=1.2e-12 PD=4.6e-06 PS=4.6e-06 m=1 $X=65325 $Y=6220 $dt=1
M11 19 19 19 19 nmos1v2hvt L=4e-06 W=4e-06 AD=1.2e-12 AS=1.2e-12 PD=4.6e-06 PS=4.6e-06 m=1 $X=70565 $Y=6220 $dt=1
M12 19 19 19 19 nmos1v2hvt L=4e-06 W=4e-06 AD=1.2e-12 AS=1.2e-12 PD=4.6e-06 PS=4.6e-06 m=1 $X=70565 $Y=11440 $dt=1
.ends BG_TRIM_4_fL
