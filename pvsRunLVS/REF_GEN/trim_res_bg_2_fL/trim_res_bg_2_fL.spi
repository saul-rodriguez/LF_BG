* +++++++++++++++++++++++++++++++++++++++++++++++++++++++++ *
* CDL Netlist:                                              *
*                                                           *
* Cell Name  : trim_res_bg_2_fL                             *
* Netlisted  : Tue Jun 16 05:32:09 2026                     *
* PVS Version: 24.11-s045 Mon Jan 27 22:18:54 PST 2025      *
* +++++++++++++++++++++++++++++++++++++++++++++++++++++++++ *
*.LDD
*.DEVTMPLT 0 R(rnpolyh) RNPOLYHNW1V2 POLYG3(POS) POLYG3(NEG) NW1V2(SUB)

* +++++++++++++++++++++++++++++++++++++++++++++++++++++++++ *
* Sub cell: rnpolyh_CDNS_781587925690                       *
* +++++++++++++++++++++++++++++++++++++++++++++++++++++++++ *
.subckt rnpolyh_CDNS_781587925690 2 3 4
** N=4 EP=3 FDC=5
R0 3 2 37927.7 L=1e-05 W=5e-07 $[rnpolyh] $SUB=4 $X=0 $Y=0 $dt=0
R1 3 2 37927.7 L=1e-05 W=5e-07 $[rnpolyh] $SUB=4 $X=750 $Y=0 $dt=0
R2 3 2 37927.7 L=1e-05 W=5e-07 $[rnpolyh] $SUB=4 $X=1500 $Y=0 $dt=0
R3 3 2 37927.7 L=1e-05 W=5e-07 $[rnpolyh] $SUB=4 $X=2250 $Y=0 $dt=0
R4 3 2 37927.7 L=1e-05 W=5e-07 $[rnpolyh] $SUB=4 $X=3000 $Y=0 $dt=0
.ends rnpolyh_CDNS_781587925690

* +++++++++++++++++++++++++++++++++++++++++++++++++++++++++ *
* Sub cell: rnpolyh_CDNS_781587925692                       *
* +++++++++++++++++++++++++++++++++++++++++++++++++++++++++ *
.subckt rnpolyh_CDNS_781587925692 2 3 4
** N=4 EP=3 FDC=2
R0 3 2 37927.7 L=1e-05 W=5e-07 $[rnpolyh] $SUB=4 $X=0 $Y=0 $dt=0
R1 3 2 37927.7 L=1e-05 W=5e-07 $[rnpolyh] $SUB=4 $X=750 $Y=0 $dt=0
.ends rnpolyh_CDNS_781587925692

* +++++++++++++++++++++++++++++++++++++++++++++++++++++++++ *
* Sub cell: rnpolyh_CDNS_781587925693                       *
* +++++++++++++++++++++++++++++++++++++++++++++++++++++++++ *
.subckt rnpolyh_CDNS_781587925693 2 3 4
** N=47 EP=3 FDC=44
R0 2 10 37927.7 L=1e-05 W=5e-07 $[rnpolyh] $SUB=4 $X=0 $Y=0 $dt=0
R1 5 10 37927.7 L=1e-05 W=5e-07 $[rnpolyh] $SUB=4 $X=750 $Y=0 $dt=0
R2 5 11 37927.7 L=1e-05 W=5e-07 $[rnpolyh] $SUB=4 $X=1500 $Y=0 $dt=0
R3 6 11 37927.7 L=1e-05 W=5e-07 $[rnpolyh] $SUB=4 $X=2250 $Y=0 $dt=0
R4 6 12 37927.7 L=1e-05 W=5e-07 $[rnpolyh] $SUB=4 $X=3000 $Y=0 $dt=0
R5 7 12 37927.7 L=1e-05 W=5e-07 $[rnpolyh] $SUB=4 $X=3750 $Y=0 $dt=0
R6 7 13 37927.7 L=1e-05 W=5e-07 $[rnpolyh] $SUB=4 $X=4500 $Y=0 $dt=0
R7 8 13 37927.7 L=1e-05 W=5e-07 $[rnpolyh] $SUB=4 $X=5250 $Y=0 $dt=0
R8 8 14 37927.7 L=1e-05 W=5e-07 $[rnpolyh] $SUB=4 $X=6000 $Y=0 $dt=0
R9 9 14 37927.7 L=1e-05 W=5e-07 $[rnpolyh] $SUB=4 $X=6750 $Y=0 $dt=0
R10 9 15 37927.7 L=1e-05 W=5e-07 $[rnpolyh] $SUB=4 $X=7500 $Y=0 $dt=0
R11 16 15 37927.7 L=1e-05 W=5e-07 $[rnpolyh] $SUB=4 $X=8250 $Y=0 $dt=0
R12 16 22 37927.7 L=1e-05 W=5e-07 $[rnpolyh] $SUB=4 $X=9000 $Y=0 $dt=0
R13 17 22 37927.7 L=1e-05 W=5e-07 $[rnpolyh] $SUB=4 $X=9750 $Y=0 $dt=0
R14 17 23 37927.7 L=1e-05 W=5e-07 $[rnpolyh] $SUB=4 $X=10500 $Y=0 $dt=0
R15 18 23 37927.7 L=1e-05 W=5e-07 $[rnpolyh] $SUB=4 $X=11250 $Y=0 $dt=0
R16 18 24 37927.7 L=1e-05 W=5e-07 $[rnpolyh] $SUB=4 $X=12000 $Y=0 $dt=0
R17 19 24 37927.7 L=1e-05 W=5e-07 $[rnpolyh] $SUB=4 $X=12750 $Y=0 $dt=0
R18 19 25 37927.7 L=1e-05 W=5e-07 $[rnpolyh] $SUB=4 $X=13500 $Y=0 $dt=0
R19 20 25 37927.7 L=1e-05 W=5e-07 $[rnpolyh] $SUB=4 $X=14250 $Y=0 $dt=0
R20 20 26 37927.7 L=1e-05 W=5e-07 $[rnpolyh] $SUB=4 $X=15000 $Y=0 $dt=0
R21 21 26 37927.7 L=1e-05 W=5e-07 $[rnpolyh] $SUB=4 $X=15750 $Y=0 $dt=0
R22 21 32 37927.7 L=1e-05 W=5e-07 $[rnpolyh] $SUB=4 $X=16500 $Y=0 $dt=0
R23 27 32 37927.7 L=1e-05 W=5e-07 $[rnpolyh] $SUB=4 $X=17250 $Y=0 $dt=0
R24 27 33 37927.7 L=1e-05 W=5e-07 $[rnpolyh] $SUB=4 $X=18000 $Y=0 $dt=0
R25 28 33 37927.7 L=1e-05 W=5e-07 $[rnpolyh] $SUB=4 $X=18750 $Y=0 $dt=0
R26 28 34 37927.7 L=1e-05 W=5e-07 $[rnpolyh] $SUB=4 $X=19500 $Y=0 $dt=0
R27 29 34 37927.7 L=1e-05 W=5e-07 $[rnpolyh] $SUB=4 $X=20250 $Y=0 $dt=0
R28 29 35 37927.7 L=1e-05 W=5e-07 $[rnpolyh] $SUB=4 $X=21000 $Y=0 $dt=0
R29 30 35 37927.7 L=1e-05 W=5e-07 $[rnpolyh] $SUB=4 $X=21750 $Y=0 $dt=0
R30 30 36 37927.7 L=1e-05 W=5e-07 $[rnpolyh] $SUB=4 $X=22500 $Y=0 $dt=0
R31 31 36 37927.7 L=1e-05 W=5e-07 $[rnpolyh] $SUB=4 $X=23250 $Y=0 $dt=0
R32 31 37 37927.7 L=1e-05 W=5e-07 $[rnpolyh] $SUB=4 $X=24000 $Y=0 $dt=0
R33 38 37 37927.7 L=1e-05 W=5e-07 $[rnpolyh] $SUB=4 $X=24750 $Y=0 $dt=0
R34 38 43 37927.7 L=1e-05 W=5e-07 $[rnpolyh] $SUB=4 $X=25500 $Y=0 $dt=0
R35 39 43 37927.7 L=1e-05 W=5e-07 $[rnpolyh] $SUB=4 $X=26250 $Y=0 $dt=0
R36 39 44 37927.7 L=1e-05 W=5e-07 $[rnpolyh] $SUB=4 $X=27000 $Y=0 $dt=0
R37 40 44 37927.7 L=1e-05 W=5e-07 $[rnpolyh] $SUB=4 $X=27750 $Y=0 $dt=0
R38 40 45 37927.7 L=1e-05 W=5e-07 $[rnpolyh] $SUB=4 $X=28500 $Y=0 $dt=0
R39 41 45 37927.7 L=1e-05 W=5e-07 $[rnpolyh] $SUB=4 $X=29250 $Y=0 $dt=0
R40 41 46 37927.7 L=1e-05 W=5e-07 $[rnpolyh] $SUB=4 $X=30000 $Y=0 $dt=0
R41 42 46 37927.7 L=1e-05 W=5e-07 $[rnpolyh] $SUB=4 $X=30750 $Y=0 $dt=0
R42 42 47 37927.7 L=1e-05 W=5e-07 $[rnpolyh] $SUB=4 $X=31500 $Y=0 $dt=0
R43 3 47 37927.7 L=1e-05 W=5e-07 $[rnpolyh] $SUB=4 $X=32250 $Y=0 $dt=0
.ends rnpolyh_CDNS_781587925693

* +++++++++++++++++++++++++++++++++++++++++++++++++++++++++ *
* Sub cell: rnpolyh_CDNS_781587925694                       *
* +++++++++++++++++++++++++++++++++++++++++++++++++++++++++ *
.subckt rnpolyh_CDNS_781587925694 2
** N=2 EP=1 FDC=1
R0 2 2 37927.7 L=1e-05 W=5e-07 $[rnpolyh] $SUB=2 $X=0 $Y=0 $dt=0
.ends rnpolyh_CDNS_781587925694

* +++++++++++++++++++++++++++++++++++++++++++++++++++++++++ *
* Sub cell: trim_res_bg_2_fL                                *
* +++++++++++++++++++++++++++++++++++++++++++++++++++++++++ *
.subckt trim_res_bg_2_fL P1 P2 REF S0 S1 S2 S3 S4 S5 S6
+ S7
** N=16 EP=11 FDC=100
X0 P2 S7 REF rnpolyh_CDNS_781587925690 $T=7665 11655 0 180 $X=3915 $Y=915
X1 S7 S6 REF rnpolyh_CDNS_781587925690 $T=11415 1655 1 180 $X=7665 $Y=915
X2 S6 S5 REF rnpolyh_CDNS_781587925690 $T=15165 11655 0 180 $X=11415 $Y=915
X3 S5 S4 REF rnpolyh_CDNS_781587925690 $T=18915 1655 1 180 $X=15165 $Y=915
X4 S4 S3 REF rnpolyh_CDNS_781587925690 $T=22665 11655 0 180 $X=18915 $Y=915
X5 S3 S2 REF rnpolyh_CDNS_781587925690 $T=26415 1655 1 180 $X=22665 $Y=915
X6 S2 S1 REF rnpolyh_CDNS_781587925690 $T=30165 11655 0 180 $X=26415 $Y=915
X7 S1 S0 REF rnpolyh_CDNS_781587925690 $T=33915 1655 1 180 $X=30165 $Y=915
X8 S0 12 REF rnpolyh_CDNS_781587925690 $T=37665 11655 0 180 $X=33915 $Y=915
X9 13 14 REF rnpolyh_CDNS_781587925692 $T=34915 13055 0 0 $X=34665 $Y=12315
X10 12 13 REF rnpolyh_CDNS_781587925692 $T=36415 23055 1 0 $X=36165 $Y=12315
X11 P1 14 REF rnpolyh_CDNS_781587925693 $T=1915 13055 0 0 $X=1665 $Y=12315
X12 REF rnpolyh_CDNS_781587925694 $T=1665 1655 1 180 $X=915 $Y=915
X13 REF rnpolyh_CDNS_781587925694 $T=1165 13055 0 0 $X=915 $Y=12315
X14 REF rnpolyh_CDNS_781587925694 $T=2415 1655 1 180 $X=1665 $Y=915
X15 REF rnpolyh_CDNS_781587925694 $T=3165 1655 1 180 $X=2415 $Y=915
X16 REF rnpolyh_CDNS_781587925694 $T=3915 1655 1 180 $X=3165 $Y=915
X17 REF rnpolyh_CDNS_781587925694 $T=38415 1655 1 180 $X=37665 $Y=915
X18 REF rnpolyh_CDNS_781587925694 $T=37915 13055 0 0 $X=37665 $Y=12315
.ends trim_res_bg_2_fL
