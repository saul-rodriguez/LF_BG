* +++++++++++++++++++++++++++++++++++++++++++++++++++++++++ *
* CDL Netlist:                                              *
*                                                           *
* Cell Name  : CONSTANT_GM_2_fL                             *
* Netlisted  : Mon Jun 15 11:23:03 2026                     *
* PVS Version: 24.11-s045 Mon Jan 27 22:18:54 PST 2025      *
* +++++++++++++++++++++++++++++++++++++++++++++++++++++++++ *
*.LDD
*.DEVTMPLT 0 MN(nmos1v2hvt) NMOS1V2HVT NDIFF(D) NGATE(G) NDIFF(S) PW1V2(B)
*.DEVTMPLT 1 MP(pmos1v2hvt) PMOS1V2HVT PDIFF(D) PGATE(G) PDIFF(S) NW1V2(B)
*.DEVTMPLT 2 ncap1v2hvt() NCAP1V2HVT NGATE(PLUS) NDIFF(MINUS) PW1V2(B)
*.DEVTMPLT 3 R(rnpolym) RNPOLYMNW1V2 POLYG3(POS) POLYG3(NEG) NW1V2(SUB)

* +++++++++++++++++++++++++++++++++++++++++++++++++++++++++ *
* Sub cell: ncap1v2hvt                                      *
* +++++++++++++++++++++++++++++++++++++++++++++++++++++++++ *
.subckt ncap1v2hvt PLUS MINUS B
.ends ncap1v2hvt

* +++++++++++++++++++++++++++++++++++++++++++++++++++++++++ *
* Sub cell: nmos1v2hvt_4_CDNS_781522578890                  *
* +++++++++++++++++++++++++++++++++++++++++++++++++++++++++ *
.subckt nmos1v2hvt_4_CDNS_781522578890 1 2 3 4
** N=4 EP=4 FDC=1
M0 3 1 2 4 nmos1v2hvt L=2e-06 W=1e-05 AD=3e-12 AS=3e-12 PD=1.06e-05 PS=1.06e-05 m=1 $X=0 $Y=0 $dt=0
.ends nmos1v2hvt_4_CDNS_781522578890

* +++++++++++++++++++++++++++++++++++++++++++++++++++++++++ *
* Sub cell: nmos1v2hvt_4_CDNS_781522578895                  *
* +++++++++++++++++++++++++++++++++++++++++++++++++++++++++ *
.subckt nmos1v2hvt_4_CDNS_781522578895 1 2 3
** N=3 EP=3 FDC=1
M0 3 1 2 2 nmos1v2hvt L=5e-07 W=1e-06 AD=3e-13 AS=3e-13 PD=1.6e-06 PS=1.6e-06 m=1 $X=0 $Y=0 $dt=0
.ends nmos1v2hvt_4_CDNS_781522578895

* +++++++++++++++++++++++++++++++++++++++++++++++++++++++++ *
* Sub cell: nmos1v2hvt_4_CDNS_781522578898                  *
* +++++++++++++++++++++++++++++++++++++++++++++++++++++++++ *
.subckt nmos1v2hvt_4_CDNS_781522578898 1 2 3 4
** N=4 EP=4 FDC=1
M0 4 1 2 3 nmos1v2hvt L=1e-05 W=1e-05 AD=3e-12 AS=3e-12 PD=1.06e-05 PS=1.06e-05 m=1 $X=0 $Y=0 $dt=0
.ends nmos1v2hvt_4_CDNS_781522578898

* +++++++++++++++++++++++++++++++++++++++++++++++++++++++++ *
* Sub cell: pmos1v2hvt_4_CDNS_7815225788911                 *
* +++++++++++++++++++++++++++++++++++++++++++++++++++++++++ *
.subckt pmos1v2hvt_4_CDNS_7815225788911 1 2 3
** N=4 EP=3 FDC=1
M0 3 1 2 2 pmos1v2hvt L=5e-06 W=1e-05 AD=3e-12 AS=3e-12 PD=1.06e-05 PS=1.06e-05 m=1 $X=0 $Y=0 $dt=1
.ends pmos1v2hvt_4_CDNS_7815225788911

* +++++++++++++++++++++++++++++++++++++++++++++++++++++++++ *
* Sub cell: pmos1v2hvt_4_CDNS_7815225788914                 *
* +++++++++++++++++++++++++++++++++++++++++++++++++++++++++ *
.subckt pmos1v2hvt_4_CDNS_7815225788914 1 2 3
** N=4 EP=3 FDC=1
M0 1 1 2 3 pmos1v2hvt L=5e-07 W=1e-06 AD=3e-13 AS=3e-13 PD=1.6e-06 PS=1.6e-06 m=1 $X=0 $Y=0 $dt=1
.ends pmos1v2hvt_4_CDNS_7815225788914

* +++++++++++++++++++++++++++++++++++++++++++++++++++++++++ *
* Sub cell: nmos1v2hvt_4_CDNS_7815225788916                 *
* +++++++++++++++++++++++++++++++++++++++++++++++++++++++++ *
.subckt nmos1v2hvt_4_CDNS_7815225788916 1 2
** N=2 EP=2 FDC=1
M0 1 1 2 2 nmos1v2hvt L=2e-06 W=1e-05 AD=3e-12 AS=3e-12 PD=1.06e-05 PS=1.06e-05 m=1 $X=0 $Y=0 $dt=0
.ends nmos1v2hvt_4_CDNS_7815225788916

* +++++++++++++++++++++++++++++++++++++++++++++++++++++++++ *
* Sub cell: pmos1v2hvt_4_CDNS_7815225788917                 *
* +++++++++++++++++++++++++++++++++++++++++++++++++++++++++ *
.subckt pmos1v2hvt_4_CDNS_7815225788917 1 2 3
** N=4 EP=3 FDC=1
M0 3 1 2 2 pmos1v2hvt L=5e-07 W=2e-06 AD=6e-13 AS=6e-13 PD=2.6e-06 PS=2.6e-06 m=1 $X=0 $Y=0 $dt=1
.ends pmos1v2hvt_4_CDNS_7815225788917

* +++++++++++++++++++++++++++++++++++++++++++++++++++++++++ *
* Sub cell: nmos1v2hvt_4_CDNS_7815225788919                 *
* +++++++++++++++++++++++++++++++++++++++++++++++++++++++++ *
.subckt nmos1v2hvt_4_CDNS_7815225788919 1 2 3
** N=3 EP=3 FDC=1
M0 3 1 2 2 nmos1v2hvt L=1e-06 W=1e-06 AD=3e-13 AS=3e-13 PD=1.6e-06 PS=1.6e-06 m=1 $X=0 $Y=0 $dt=0
.ends nmos1v2hvt_4_CDNS_7815225788919

* +++++++++++++++++++++++++++++++++++++++++++++++++++++++++ *
* Sub cell: pmos1v2hvt_4_CDNS_7815225788921                 *
* +++++++++++++++++++++++++++++++++++++++++++++++++++++++++ *
.subckt pmos1v2hvt_4_CDNS_7815225788921 1 2 3
** N=4 EP=3 FDC=1
M0 3 1 2 2 pmos1v2hvt L=1e-06 W=2e-06 AD=6e-13 AS=6e-13 PD=2.6e-06 PS=2.6e-06 m=1 $X=0 $Y=0 $dt=1
.ends pmos1v2hvt_4_CDNS_7815225788921

* +++++++++++++++++++++++++++++++++++++++++++++++++++++++++ *
* Sub cell: ncap1v2hvt_CDNS_7815225788923                   *
* +++++++++++++++++++++++++++++++++++++++++++++++++++++++++ *
.subckt ncap1v2hvt_CDNS_7815225788923 1 2
** N=2 EP=2 FDC=1
X3 1 2 2 ncap1v2hvt c=2.218e-24 w=2e-05 l=1e-05 as=6e-12 ad=6e-12 ps=4.06e-05 pd=4.06e-05 m=1 $X=0 $Y=0 $dt=2
.ends ncap1v2hvt_CDNS_7815225788923

* +++++++++++++++++++++++++++++++++++++++++++++++++++++++++ *
* Sub cell: rnpolym_CDNS_7815225788926                      *
* +++++++++++++++++++++++++++++++++++++++++++++++++++++++++ *
.subckt rnpolym_CDNS_7815225788926 1 2 3
** N=77 EP=3 FDC=75
R0 1 6 4798.33 L=1e-05 W=5e-07 $[rnpolym] $SUB=3 $X=0 $Y=0 $dt=3
R1 4 6 4798.33 L=1e-05 W=5e-07 $[rnpolym] $SUB=3 $X=750 $Y=0 $dt=3
R2 4 7 4798.33 L=1e-05 W=5e-07 $[rnpolym] $SUB=3 $X=1500 $Y=0 $dt=3
R3 5 7 4798.33 L=1e-05 W=5e-07 $[rnpolym] $SUB=3 $X=2250 $Y=0 $dt=3
R4 5 8 4798.33 L=1e-05 W=5e-07 $[rnpolym] $SUB=3 $X=3000 $Y=0 $dt=3
R5 9 8 4798.33 L=1e-05 W=5e-07 $[rnpolym] $SUB=3 $X=3750 $Y=0 $dt=3
R6 9 12 4798.33 L=1e-05 W=5e-07 $[rnpolym] $SUB=3 $X=4500 $Y=0 $dt=3
R7 10 12 4798.33 L=1e-05 W=5e-07 $[rnpolym] $SUB=3 $X=5250 $Y=0 $dt=3
R8 10 13 4798.33 L=1e-05 W=5e-07 $[rnpolym] $SUB=3 $X=6000 $Y=0 $dt=3
R9 11 13 4798.33 L=1e-05 W=5e-07 $[rnpolym] $SUB=3 $X=6750 $Y=0 $dt=3
R10 11 16 4798.33 L=1e-05 W=5e-07 $[rnpolym] $SUB=3 $X=7500 $Y=0 $dt=3
R11 14 16 4798.33 L=1e-05 W=5e-07 $[rnpolym] $SUB=3 $X=8250 $Y=0 $dt=3
R12 14 17 4798.33 L=1e-05 W=5e-07 $[rnpolym] $SUB=3 $X=9000 $Y=0 $dt=3
R13 15 17 4798.33 L=1e-05 W=5e-07 $[rnpolym] $SUB=3 $X=9750 $Y=0 $dt=3
R14 15 18 4798.33 L=1e-05 W=5e-07 $[rnpolym] $SUB=3 $X=10500 $Y=0 $dt=3
R15 19 18 4798.33 L=1e-05 W=5e-07 $[rnpolym] $SUB=3 $X=11250 $Y=0 $dt=3
R16 19 22 4798.33 L=1e-05 W=5e-07 $[rnpolym] $SUB=3 $X=12000 $Y=0 $dt=3
R17 20 22 4798.33 L=1e-05 W=5e-07 $[rnpolym] $SUB=3 $X=12750 $Y=0 $dt=3
R18 20 23 4798.33 L=1e-05 W=5e-07 $[rnpolym] $SUB=3 $X=13500 $Y=0 $dt=3
R19 21 23 4798.33 L=1e-05 W=5e-07 $[rnpolym] $SUB=3 $X=14250 $Y=0 $dt=3
R20 21 26 4798.33 L=1e-05 W=5e-07 $[rnpolym] $SUB=3 $X=15000 $Y=0 $dt=3
R21 24 26 4798.33 L=1e-05 W=5e-07 $[rnpolym] $SUB=3 $X=15750 $Y=0 $dt=3
R22 24 27 4798.33 L=1e-05 W=5e-07 $[rnpolym] $SUB=3 $X=16500 $Y=0 $dt=3
R23 25 27 4798.33 L=1e-05 W=5e-07 $[rnpolym] $SUB=3 $X=17250 $Y=0 $dt=3
R24 25 28 4798.33 L=1e-05 W=5e-07 $[rnpolym] $SUB=3 $X=18000 $Y=0 $dt=3
R25 29 28 4798.33 L=1e-05 W=5e-07 $[rnpolym] $SUB=3 $X=18750 $Y=0 $dt=3
R26 29 32 4798.33 L=1e-05 W=5e-07 $[rnpolym] $SUB=3 $X=19500 $Y=0 $dt=3
R27 30 32 4798.33 L=1e-05 W=5e-07 $[rnpolym] $SUB=3 $X=20250 $Y=0 $dt=3
R28 30 33 4798.33 L=1e-05 W=5e-07 $[rnpolym] $SUB=3 $X=21000 $Y=0 $dt=3
R29 31 33 4798.33 L=1e-05 W=5e-07 $[rnpolym] $SUB=3 $X=21750 $Y=0 $dt=3
R30 31 36 4798.33 L=1e-05 W=5e-07 $[rnpolym] $SUB=3 $X=22500 $Y=0 $dt=3
R31 34 36 4798.33 L=1e-05 W=5e-07 $[rnpolym] $SUB=3 $X=23250 $Y=0 $dt=3
R32 34 37 4798.33 L=1e-05 W=5e-07 $[rnpolym] $SUB=3 $X=24000 $Y=0 $dt=3
R33 35 37 4798.33 L=1e-05 W=5e-07 $[rnpolym] $SUB=3 $X=24750 $Y=0 $dt=3
R34 35 38 4798.33 L=1e-05 W=5e-07 $[rnpolym] $SUB=3 $X=25500 $Y=0 $dt=3
R35 39 38 4798.33 L=1e-05 W=5e-07 $[rnpolym] $SUB=3 $X=26250 $Y=0 $dt=3
R36 39 42 4798.33 L=1e-05 W=5e-07 $[rnpolym] $SUB=3 $X=27000 $Y=0 $dt=3
R37 40 42 4798.33 L=1e-05 W=5e-07 $[rnpolym] $SUB=3 $X=27750 $Y=0 $dt=3
R38 40 43 4798.33 L=1e-05 W=5e-07 $[rnpolym] $SUB=3 $X=28500 $Y=0 $dt=3
R39 41 43 4798.33 L=1e-05 W=5e-07 $[rnpolym] $SUB=3 $X=29250 $Y=0 $dt=3
R40 41 46 4798.33 L=1e-05 W=5e-07 $[rnpolym] $SUB=3 $X=30000 $Y=0 $dt=3
R41 44 46 4798.33 L=1e-05 W=5e-07 $[rnpolym] $SUB=3 $X=30750 $Y=0 $dt=3
R42 44 47 4798.33 L=1e-05 W=5e-07 $[rnpolym] $SUB=3 $X=31500 $Y=0 $dt=3
R43 45 47 4798.33 L=1e-05 W=5e-07 $[rnpolym] $SUB=3 $X=32250 $Y=0 $dt=3
R44 45 48 4798.33 L=1e-05 W=5e-07 $[rnpolym] $SUB=3 $X=33000 $Y=0 $dt=3
R45 49 48 4798.33 L=1e-05 W=5e-07 $[rnpolym] $SUB=3 $X=33750 $Y=0 $dt=3
R46 49 52 4798.33 L=1e-05 W=5e-07 $[rnpolym] $SUB=3 $X=34500 $Y=0 $dt=3
R47 50 52 4798.33 L=1e-05 W=5e-07 $[rnpolym] $SUB=3 $X=35250 $Y=0 $dt=3
R48 50 53 4798.33 L=1e-05 W=5e-07 $[rnpolym] $SUB=3 $X=36000 $Y=0 $dt=3
R49 51 53 4798.33 L=1e-05 W=5e-07 $[rnpolym] $SUB=3 $X=36750 $Y=0 $dt=3
R50 51 56 4798.33 L=1e-05 W=5e-07 $[rnpolym] $SUB=3 $X=37500 $Y=0 $dt=3
R51 54 56 4798.33 L=1e-05 W=5e-07 $[rnpolym] $SUB=3 $X=38250 $Y=0 $dt=3
R52 54 57 4798.33 L=1e-05 W=5e-07 $[rnpolym] $SUB=3 $X=39000 $Y=0 $dt=3
R53 55 57 4798.33 L=1e-05 W=5e-07 $[rnpolym] $SUB=3 $X=39750 $Y=0 $dt=3
R54 55 58 4798.33 L=1e-05 W=5e-07 $[rnpolym] $SUB=3 $X=40500 $Y=0 $dt=3
R55 59 58 4798.33 L=1e-05 W=5e-07 $[rnpolym] $SUB=3 $X=41250 $Y=0 $dt=3
R56 59 62 4798.33 L=1e-05 W=5e-07 $[rnpolym] $SUB=3 $X=42000 $Y=0 $dt=3
R57 60 62 4798.33 L=1e-05 W=5e-07 $[rnpolym] $SUB=3 $X=42750 $Y=0 $dt=3
R58 60 63 4798.33 L=1e-05 W=5e-07 $[rnpolym] $SUB=3 $X=43500 $Y=0 $dt=3
R59 61 63 4798.33 L=1e-05 W=5e-07 $[rnpolym] $SUB=3 $X=44250 $Y=0 $dt=3
R60 61 66 4798.33 L=1e-05 W=5e-07 $[rnpolym] $SUB=3 $X=45000 $Y=0 $dt=3
R61 64 66 4798.33 L=1e-05 W=5e-07 $[rnpolym] $SUB=3 $X=45750 $Y=0 $dt=3
R62 64 67 4798.33 L=1e-05 W=5e-07 $[rnpolym] $SUB=3 $X=46500 $Y=0 $dt=3
R63 65 67 4798.33 L=1e-05 W=5e-07 $[rnpolym] $SUB=3 $X=47250 $Y=0 $dt=3
R64 65 68 4798.33 L=1e-05 W=5e-07 $[rnpolym] $SUB=3 $X=48000 $Y=0 $dt=3
R65 69 68 4798.33 L=1e-05 W=5e-07 $[rnpolym] $SUB=3 $X=48750 $Y=0 $dt=3
R66 69 72 4798.33 L=1e-05 W=5e-07 $[rnpolym] $SUB=3 $X=49500 $Y=0 $dt=3
R67 70 72 4798.33 L=1e-05 W=5e-07 $[rnpolym] $SUB=3 $X=50250 $Y=0 $dt=3
R68 70 73 4798.33 L=1e-05 W=5e-07 $[rnpolym] $SUB=3 $X=51000 $Y=0 $dt=3
R69 71 73 4798.33 L=1e-05 W=5e-07 $[rnpolym] $SUB=3 $X=51750 $Y=0 $dt=3
R70 71 76 4798.33 L=1e-05 W=5e-07 $[rnpolym] $SUB=3 $X=52500 $Y=0 $dt=3
R71 74 76 4798.33 L=1e-05 W=5e-07 $[rnpolym] $SUB=3 $X=53250 $Y=0 $dt=3
R72 74 77 4798.33 L=1e-05 W=5e-07 $[rnpolym] $SUB=3 $X=54000 $Y=0 $dt=3
R73 75 77 4798.33 L=1e-05 W=5e-07 $[rnpolym] $SUB=3 $X=54750 $Y=0 $dt=3
R74 75 2 4798.33 L=1e-05 W=5e-07 $[rnpolym] $SUB=3 $X=55500 $Y=0 $dt=3
.ends rnpolym_CDNS_7815225788926

* +++++++++++++++++++++++++++++++++++++++++++++++++++++++++ *
* Sub cell: pmos1v2hvt_4_CDNS_7815225788928                 *
* +++++++++++++++++++++++++++++++++++++++++++++++++++++++++ *
.subckt pmos1v2hvt_4_CDNS_7815225788928 1 2 3 4
** N=5 EP=4 FDC=1
M0 3 1 2 4 pmos1v2hvt L=5e-06 W=1e-05 AD=3e-12 AS=3e-12 PD=1.06e-05 PS=1.06e-05 m=1 $X=0 $Y=0 $dt=1
.ends pmos1v2hvt_4_CDNS_7815225788928

* +++++++++++++++++++++++++++++++++++++++++++++++++++++++++ *
* Sub cell: pmos1v2hvt_4_CDNS_7815225788929                 *
* +++++++++++++++++++++++++++++++++++++++++++++++++++++++++ *
.subckt pmos1v2hvt_4_CDNS_7815225788929 1 2 3 4
** N=5 EP=4 FDC=4
M0 3 1 2 4 pmos1v2hvt L=5e-06 W=1e-05 AD=3.4e-12 AS=3e-12 PD=1.068e-05 PS=1.06e-05 m=1 $X=0 $Y=0 $dt=1
M1 2 1 3 4 pmos1v2hvt L=5e-06 W=1e-05 AD=3.4e-12 AS=3.4e-12 PD=1.068e-05 PS=1.068e-05 m=1 $X=5340 $Y=0 $dt=1
M2 3 1 2 4 pmos1v2hvt L=5e-06 W=1e-05 AD=3.4e-12 AS=3.4e-12 PD=1.068e-05 PS=1.068e-05 m=1 $X=10680 $Y=0 $dt=1
M3 2 1 3 4 pmos1v2hvt L=5e-06 W=1e-05 AD=3e-12 AS=3.4e-12 PD=1.06e-05 PS=1.068e-05 m=1 $X=16020 $Y=0 $dt=1
.ends pmos1v2hvt_4_CDNS_7815225788929

* +++++++++++++++++++++++++++++++++++++++++++++++++++++++++ *
* Sub cell: CONSTANT_GM_2_fL                                *
* +++++++++++++++++++++++++++++++++++++++++++++++++++++++++ *
.subckt CONSTANT_GM_2_fL EN GNDA IOUT1 IOUT2 VDDA
** N=18 EP=5 FDC=199
X29 7 8 13 GNDA nmos1v2hvt_4_CDNS_781522578890 $T=15235 31755 0 0 $X=14615 $Y=31035
X30 7 8 13 GNDA nmos1v2hvt_4_CDNS_781522578890 $T=18475 31755 0 0 $X=17855 $Y=31035
X31 7 8 13 GNDA nmos1v2hvt_4_CDNS_781522578890 $T=24955 31755 0 0 $X=24335 $Y=31035
X32 7 8 13 GNDA nmos1v2hvt_4_CDNS_781522578890 $T=28195 31755 0 0 $X=27575 $Y=31035
X33 EN GNDA 2 nmos1v2hvt_4_CDNS_781522578895 $T=3870 7605 0 0 $X=3250 $Y=6885
X34 2 GNDA 3 nmos1v2hvt_4_CDNS_781522578895 $T=5610 7605 0 0 $X=4990 $Y=6885
X35 4 7 GNDA 4 nmos1v2hvt_4_CDNS_781522578898 $T=11925 44235 0 0 $X=11305 $Y=43515
X36 4 13 GNDA 9 nmos1v2hvt_4_CDNS_781522578898 $T=33165 44235 1 180 $X=22545 $Y=43515
X37 6 VDDA 16 pmos1v2hvt_4_CDNS_7815225788911 $T=19335 92590 1 0 $X=18715 $Y=82190
X38 6 VDDA 16 pmos1v2hvt_4_CDNS_7815225788911 $T=25575 92590 1 0 $X=24955 $Y=82190
X39 6 VDDA 16 pmos1v2hvt_4_CDNS_7815225788911 $T=38055 92590 1 0 $X=37435 $Y=82190
X40 6 VDDA 16 pmos1v2hvt_4_CDNS_7815225788911 $T=44295 92590 1 0 $X=43675 $Y=82190
X41 4 5 VDDA pmos1v2hvt_4_CDNS_7815225788914 $T=18585 61645 0 0 $X=17965 $Y=60925
X42 5 9 VDDA pmos1v2hvt_4_CDNS_7815225788914 $T=19085 65035 1 180 $X=17965 $Y=64315
X43 GNDA GNDA nmos1v2hvt_4_CDNS_7815225788916 $T=11995 31755 0 0 $X=11375 $Y=31035
X44 7 GNDA nmos1v2hvt_4_CDNS_7815225788916 $T=21715 31755 0 0 $X=21095 $Y=31035
X45 GNDA GNDA nmos1v2hvt_4_CDNS_7815225788916 $T=31435 31755 0 0 $X=30815 $Y=31035
X46 EN VDDA 2 pmos1v2hvt_4_CDNS_7815225788917 $T=3870 11980 1 0 $X=3250 $Y=9580
X47 2 VDDA 3 pmos1v2hvt_4_CDNS_7815225788917 $T=5610 11980 1 0 $X=4990 $Y=9580
X48 2 GNDA 7 nmos1v2hvt_4_CDNS_7815225788919 $T=7350 7605 0 0 $X=6730 $Y=6885
X49 3 VDDA 6 pmos1v2hvt_4_CDNS_7815225788921 $T=11245 67655 1 0 $X=10625 $Y=65255
X50 IOUT2 GNDA ncap1v2hvt_CDNS_7815225788923 $T=89895 18995 1 270 $X=69495 $Y=8395
X51 IOUT2 GNDA ncap1v2hvt_CDNS_7815225788923 $T=89895 30195 1 270 $X=69495 $Y=19595
X52 IOUT2 GNDA ncap1v2hvt_CDNS_7815225788923 $T=89895 41395 1 270 $X=69495 $Y=30795
X53 IOUT2 GNDA ncap1v2hvt_CDNS_7815225788923 $T=89895 52595 1 270 $X=69495 $Y=41995
X54 IOUT1 GNDA ncap1v2hvt_CDNS_7815225788923 $T=89895 65360 1 270 $X=69495 $Y=54760
X55 IOUT1 GNDA ncap1v2hvt_CDNS_7815225788923 $T=89895 76560 1 270 $X=69495 $Y=65960
X56 IOUT1 GNDA ncap1v2hvt_CDNS_7815225788923 $T=89895 87760 1 270 $X=69495 $Y=77160
X57 IOUT1 GNDA ncap1v2hvt_CDNS_7815225788923 $T=89895 98960 1 270 $X=69495 $Y=88360
X58 17 GNDA GNDA rnpolym_CDNS_7815225788926 $T=67625 17625 0 180 $X=11375 $Y=6885
X59 8 17 GNDA rnpolym_CDNS_7815225788926 $T=11625 29025 1 0 $X=11375 $Y=18285
X60 VDDA VDDA VDDA VDDA pmos1v2hvt_4_CDNS_7815225788928 $T=13095 70970 0 0 $X=12475 $Y=70250
X61 VDDA VDDA VDDA VDDA pmos1v2hvt_4_CDNS_7815225788928 $T=13095 92590 1 0 $X=12475 $Y=82190
X62 6 VDDA 18 VDDA pmos1v2hvt_4_CDNS_7815225788928 $T=19335 70970 0 0 $X=18715 $Y=70250
X63 9 10 4 VDDA pmos1v2hvt_4_CDNS_7815225788928 $T=26920 66755 0 180 $X=21300 $Y=56355
X64 6 VDDA 18 VDDA pmos1v2hvt_4_CDNS_7815225788928 $T=25575 70970 0 0 $X=24955 $Y=70250
X65 9 6 9 VDDA pmos1v2hvt_4_CDNS_7815225788928 $T=28160 66755 1 0 $X=27540 $Y=56355
X66 6 VDDA 6 VDDA pmos1v2hvt_4_CDNS_7815225788928 $T=31815 70970 0 0 $X=31195 $Y=70250
X67 6 VDDA 10 VDDA pmos1v2hvt_4_CDNS_7815225788928 $T=31815 92590 1 0 $X=31195 $Y=82190
X68 6 VDDA 18 VDDA pmos1v2hvt_4_CDNS_7815225788928 $T=38055 70970 0 0 $X=37435 $Y=70250
X69 6 VDDA 18 VDDA pmos1v2hvt_4_CDNS_7815225788928 $T=44295 70970 0 0 $X=43675 $Y=70250
X70 VDDA VDDA VDDA VDDA pmos1v2hvt_4_CDNS_7815225788928 $T=50535 70970 0 0 $X=49915 $Y=70250
X71 VDDA VDDA VDDA VDDA pmos1v2hvt_4_CDNS_7815225788928 $T=50535 92590 1 0 $X=49915 $Y=82190
X72 9 18 IOUT2 VDDA pmos1v2hvt_4_CDNS_7815225788929 $T=36255 42185 1 0 $X=35635 $Y=31775
X73 9 16 IOUT1 VDDA pmos1v2hvt_4_CDNS_7815225788929 $T=36255 56500 1 0 $X=35635 $Y=46090
.ends CONSTANT_GM_2_fL
