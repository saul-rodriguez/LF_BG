* +++++++++++++++++++++++++++++++++++++++++++++++++++++++++ *
* CDL Netlist:                                              *
*                                                           *
* Cell Name  : mux2_1_fL                                    *
* Netlisted  : Mon Jun 15 16:02:44 2026                     *
* PVS Version: 24.11-s045 Mon Jan 27 22:18:54 PST 2025      *
* +++++++++++++++++++++++++++++++++++++++++++++++++++++++++ *
*.LDD
*.DEVTMPLT 0 MN(nmos1v2hvt) NMOS1V2HVT NDIFF(D) NGATE(G) NDIFF(S) PW1V2(B)
*.DEVTMPLT 1 MP(pmos1v2hvt) PMOS1V2HVT PDIFF(D) PGATE(G) PDIFF(S) NW1V2(B)

* +++++++++++++++++++++++++++++++++++++++++++++++++++++++++ *
* Sub cell: pmos1v2hvt_4_CDNS_781539360250                  *
* +++++++++++++++++++++++++++++++++++++++++++++++++++++++++ *
.subckt pmos1v2hvt_4_CDNS_781539360250 1 2 3 4
** N=5 EP=4 FDC=1
M0 3 1 2 4 pmos1v2hvt L=1e-06 W=4e-06 AD=1.2e-12 AS=1.2e-12 PD=4.6e-06 PS=4.6e-06 m=1 $X=0 $Y=0 $dt=1
.ends pmos1v2hvt_4_CDNS_781539360250

* +++++++++++++++++++++++++++++++++++++++++++++++++++++++++ *
* Sub cell: pmos1v2hvt_4_CDNS_781539360254                  *
* +++++++++++++++++++++++++++++++++++++++++++++++++++++++++ *
.subckt pmos1v2hvt_4_CDNS_781539360254 1 2 3
** N=4 EP=3 FDC=1
M0 3 1 2 2 pmos1v2hvt L=1e-06 W=2e-06 AD=6e-13 AS=6e-13 PD=2.6e-06 PS=2.6e-06 m=1 $X=0 $Y=0 $dt=1
.ends pmos1v2hvt_4_CDNS_781539360254

* +++++++++++++++++++++++++++++++++++++++++++++++++++++++++ *
* Sub cell: nmos1v2hvt_4_CDNS_781539360256                  *
* +++++++++++++++++++++++++++++++++++++++++++++++++++++++++ *
.subckt nmos1v2hvt_4_CDNS_781539360256 1 2 3
** N=3 EP=3 FDC=1
M0 3 1 2 2 nmos1v2hvt L=1e-06 W=1e-06 AD=3e-13 AS=3e-13 PD=1.6e-06 PS=1.6e-06 m=1 $X=0 $Y=0 $dt=0
.ends nmos1v2hvt_4_CDNS_781539360256

* +++++++++++++++++++++++++++++++++++++++++++++++++++++++++ *
* Sub cell: nmos1v2hvt_4_CDNS_781539360259                  *
* +++++++++++++++++++++++++++++++++++++++++++++++++++++++++ *
.subckt nmos1v2hvt_4_CDNS_781539360259 1 2 3 4
** N=4 EP=4 FDC=1
M0 3 1 2 4 nmos1v2hvt L=1e-06 W=2e-06 AD=6e-13 AS=6e-13 PD=2.6e-06 PS=2.6e-06 m=1 $X=0 $Y=0 $dt=0
.ends nmos1v2hvt_4_CDNS_781539360259

* +++++++++++++++++++++++++++++++++++++++++++++++++++++++++ *
* Sub cell: mux2_1_fL                                       *
* +++++++++++++++++++++++++++++++++++++++++++++++++++++++++ *
.subckt mux2_1_fL COM GNDA IN0 IN1 S VDDA
** N=7 EP=6 FDC=6
X12 S IN0 COM VDDA pmos1v2hvt_4_CDNS_781539360250 $T=3450 8710 1 0 $X=2830 $Y=4310
X13 7 IN1 COM VDDA pmos1v2hvt_4_CDNS_781539360250 $T=6690 8710 0 180 $X=5070 $Y=4310
X14 S VDDA 7 pmos1v2hvt_4_CDNS_781539360254 $T=1670 8710 0 180 $X=50 $Y=6310
X15 S GNDA 7 nmos1v2hvt_4_CDNS_781539360256 $T=1670 775 1 180 $X=50 $Y=55
X16 S COM IN1 GNDA nmos1v2hvt_4_CDNS_781539360259 $T=4450 775 1 180 $X=2830 $Y=55
X17 7 COM IN0 GNDA nmos1v2hvt_4_CDNS_781539360259 $T=5690 775 0 0 $X=5070 $Y=55
.ends mux2_1_fL
