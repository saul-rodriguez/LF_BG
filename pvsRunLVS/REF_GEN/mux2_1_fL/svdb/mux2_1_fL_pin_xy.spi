* +++++++++++++++++++++++++++++++++++++++++++++++++++++++++ *
* CDL Netlist:                                              *
*                                                           *
* Cell Name  : mux2_1_fL                                    *
* Netlisted  : Mon Jun 15 16:02:44 2026                     *
* PVS Version: 24.11-s045 Mon Jan 27 22:18:54 PST 2025      *
* +++++++++++++++++++++++++++++++++++++++++++++++++++++++++ *
*.LDD
*.DEVTMPLT 0 MN(nmos1v2hvt) NMOS1V2HVT NDIFF(D) NGATE(G) NDIFF(S) PW1V2(B)
*.DEVTMPLT 1 MP(pmos1v2hvt) PMOS1V2HVT PDIFF(D) PGATE(G) PDIFF(S) NW1V2(B)

* +++++++++++++++++++++++++++++++++++++++++++++++++++++++++ *
* Sub cell: M1_M2_CDNS_781539360250                         *
* +++++++++++++++++++++++++++++++++++++++++++++++++++++++++ *
.subckt M1_M2_CDNS_781539360250 1
** N=1 EP=1 FDC=0
.ends M1_M2_CDNS_781539360250

* +++++++++++++++++++++++++++++++++++++++++++++++++++++++++ *
* Sub cell: M1_M2_CDNS_781539360251                         *
* +++++++++++++++++++++++++++++++++++++++++++++++++++++++++ *
.subckt M1_M2_CDNS_781539360251 1
** N=1 EP=1 FDC=0
.ends M1_M2_CDNS_781539360251

* +++++++++++++++++++++++++++++++++++++++++++++++++++++++++ *
* Sub cell: M2_M3_CDNS_781539360252                         *
* +++++++++++++++++++++++++++++++++++++++++++++++++++++++++ *
.subckt M2_M3_CDNS_781539360252 1
** N=1 EP=1 FDC=0
.ends M2_M3_CDNS_781539360252

* +++++++++++++++++++++++++++++++++++++++++++++++++++++++++ *
* Sub cell: M2_M3_CDNS_781539360256                         *
* +++++++++++++++++++++++++++++++++++++++++++++++++++++++++ *
.subckt M2_M3_CDNS_781539360256 1
** N=1 EP=1 FDC=0
.ends M2_M3_CDNS_781539360256

* +++++++++++++++++++++++++++++++++++++++++++++++++++++++++ *
* Sub cell: M1_M2_CDNS_781539360257                         *
* +++++++++++++++++++++++++++++++++++++++++++++++++++++++++ *
.subckt M1_M2_CDNS_781539360257 1
** N=1 EP=1 FDC=0
.ends M1_M2_CDNS_781539360257

* +++++++++++++++++++++++++++++++++++++++++++++++++++++++++ *
* Sub cell: Contact_CDNS_781539360251                       *
* +++++++++++++++++++++++++++++++++++++++++++++++++++++++++ *
.subckt Contact_CDNS_781539360251 1
** N=1 EP=1 FDC=0
.ends Contact_CDNS_781539360251

* +++++++++++++++++++++++++++++++++++++++++++++++++++++++++ *
* Sub cell: Contact_CDNS_781539360252                       *
* +++++++++++++++++++++++++++++++++++++++++++++++++++++++++ *
.subckt Contact_CDNS_781539360252 1
** N=1 EP=1 FDC=0
.ends Contact_CDNS_781539360252

* +++++++++++++++++++++++++++++++++++++++++++++++++++++++++ *
* Sub cell: AbutContact_CDNS_781539360253                   *
* +++++++++++++++++++++++++++++++++++++++++++++++++++++++++ *
.subckt AbutContact_CDNS_781539360253 1
** N=1 EP=1 FDC=0
.ends AbutContact_CDNS_781539360253

* +++++++++++++++++++++++++++++++++++++++++++++++++++++++++ *
* Sub cell: pmos1v2hvt_4_CDNS_781539360250                  *
* +++++++++++++++++++++++++++++++++++++++++++++++++++++++++ *
.subckt pmos1v2hvt_4_CDNS_781539360250 1 2 3 4 5
** N=5 EP=5 FDC=1
X0 2 Contact_CDNS_781539360251 $T=-245 130 0 0 $X=-245 $Y=0
X1 3 Contact_CDNS_781539360251 $T=1095 130 0 0 $X=1095 $Y=0
X2 1 Contact_CDNS_781539360252 $T=70 4120 0 0 $X=0 $Y=4120
X3 4 AbutContact_CDNS_781539360253 $T=-330 -560 0 0 $X=-520 $Y=-620
M0 3 1 2 4 pmos1v2hvt L=1e-06 W=4e-06 AD=1.2e-12 AS=1.2e-12 PD=4.6e-06 PS=4.6e-06 m=1 $X=0 $Y=0 $dt=1
.ends pmos1v2hvt_4_CDNS_781539360250

* +++++++++++++++++++++++++++++++++++++++++++++++++++++++++ *
* Sub cell: Contact_CDNS_781539360255                       *
* +++++++++++++++++++++++++++++++++++++++++++++++++++++++++ *
.subckt Contact_CDNS_781539360255 1
** N=1 EP=1 FDC=0
.ends Contact_CDNS_781539360255

* +++++++++++++++++++++++++++++++++++++++++++++++++++++++++ *
* Sub cell: pmos1v2hvt_4_CDNS_781539360254                  *
* +++++++++++++++++++++++++++++++++++++++++++++++++++++++++ *
.subckt pmos1v2hvt_4_CDNS_781539360254 1 2 3 4
** N=4 EP=4 FDC=1
X0 1 Contact_CDNS_781539360252 $T=70 2120 0 0 $X=0 $Y=2120
X1 2 AbutContact_CDNS_781539360253 $T=-330 -560 0 0 $X=-520 $Y=-620
X2 2 Contact_CDNS_781539360255 $T=-245 180 0 0 $X=-245 $Y=55
X3 3 Contact_CDNS_781539360255 $T=1095 180 0 0 $X=1095 $Y=55
M0 3 1 2 2 pmos1v2hvt L=1e-06 W=2e-06 AD=6e-13 AS=6e-13 PD=2.6e-06 PS=2.6e-06 m=1 $X=0 $Y=0 $dt=1
.ends pmos1v2hvt_4_CDNS_781539360254

* +++++++++++++++++++++++++++++++++++++++++++++++++++++++++ *
* Sub cell: Contact_CDNS_781539360257                       *
* +++++++++++++++++++++++++++++++++++++++++++++++++++++++++ *
.subckt Contact_CDNS_781539360257 1
** N=1 EP=1 FDC=0
.ends Contact_CDNS_781539360257

* +++++++++++++++++++++++++++++++++++++++++++++++++++++++++ *
* Sub cell: AbutContact_CDNS_781539360258                   *
* +++++++++++++++++++++++++++++++++++++++++++++++++++++++++ *
.subckt AbutContact_CDNS_781539360258 1
** N=1 EP=1 FDC=0
.ends AbutContact_CDNS_781539360258

* +++++++++++++++++++++++++++++++++++++++++++++++++++++++++ *
* Sub cell: nmos1v2hvt_4_CDNS_781539360256                  *
* +++++++++++++++++++++++++++++++++++++++++++++++++++++++++ *
.subckt nmos1v2hvt_4_CDNS_781539360256 1 2 3
** N=3 EP=3 FDC=1
X0 1 Contact_CDNS_781539360252 $T=70 1120 0 0 $X=0 $Y=1120
X1 2 Contact_CDNS_781539360257 $T=-245 130 0 0 $X=-245 $Y=0
X2 3 Contact_CDNS_781539360257 $T=1095 130 0 0 $X=1095 $Y=0
X3 2 AbutContact_CDNS_781539360258 $T=-330 -560 0 0 $X=-520 $Y=-620
M0 3 1 2 2 nmos1v2hvt L=1e-06 W=1e-06 AD=3e-13 AS=3e-13 PD=1.6e-06 PS=1.6e-06 m=1 $X=0 $Y=0 $dt=0
.ends nmos1v2hvt_4_CDNS_781539360256

* +++++++++++++++++++++++++++++++++++++++++++++++++++++++++ *
* Sub cell: nmos1v2hvt_4_CDNS_781539360259                  *
* +++++++++++++++++++++++++++++++++++++++++++++++++++++++++ *
.subckt nmos1v2hvt_4_CDNS_781539360259 1 2 3 4
** N=4 EP=4 FDC=1
X0 1 Contact_CDNS_781539360252 $T=70 2120 0 0 $X=0 $Y=2120
X1 2 Contact_CDNS_781539360255 $T=-245 180 0 0 $X=-245 $Y=55
X2 3 Contact_CDNS_781539360255 $T=1095 180 0 0 $X=1095 $Y=55
X3 4 AbutContact_CDNS_781539360258 $T=-330 -560 0 0 $X=-520 $Y=-620
M0 3 1 2 4 nmos1v2hvt L=1e-06 W=2e-06 AD=6e-13 AS=6e-13 PD=2.6e-06 PS=2.6e-06 m=1 $X=0 $Y=0 $dt=0
.ends nmos1v2hvt_4_CDNS_781539360259

* +++++++++++++++++++++++++++++++++++++++++++++++++++++++++ *
* Sub cell: mux2_1_fL                                       *
* +++++++++++++++++++++++++++++++++++++++++++++++++++++++++ *
.subckt mux2_1_fL 4 6 1 2 3 5
** N=7 EP=6 FDC=6
X0 1 M1_M2_CDNS_781539360250 $T=3280 6760 0 0 $X=3175 $Y=4875
X1 2 M1_M2_CDNS_781539360250 $T=6860 6760 0 0 $X=6755 $Y=4875
X2 2 M1_M2_CDNS_781539360251 $T=3280 1775 0 0 $X=3175 $Y=940
X3 1 M1_M2_CDNS_781539360251 $T=6860 1775 0 0 $X=6755 $Y=940
X4 2 M2_M3_CDNS_781539360252 $T=2190 4105 0 0 $X=1860 $Y=3950
X5 1 M2_M3_CDNS_781539360252 $T=3070 3640 0 0 $X=2740 $Y=3485
X6 2 M2_M3_CDNS_781539360252 $T=7090 4105 0 0 $X=6760 $Y=3950
X7 1 M2_M3_CDNS_781539360252 $T=7920 3640 0 0 $X=7590 $Y=3485
X8 3 M2_M3_CDNS_781539360256 $T=1165 6240 0 0 $X=835 $Y=5890
X9 4 M2_M3_CDNS_781539360256 $T=5070 8210 0 0 $X=4740 $Y=7860
X10 3 M1_M2_CDNS_781539360257 $T=1165 6240 0 0 $X=835 $Y=5890
X11 4 M1_M2_CDNS_781539360257 $T=5070 8210 0 0 $X=4740 $Y=7860
X12 3 1 4 5 6 pmos1v2hvt_4_CDNS_781539360250 $T=3450 8710 1 0 $X=2830 $Y=4310
X13 7 2 4 5 6 pmos1v2hvt_4_CDNS_781539360250 $T=6690 8710 0 180 $X=5070 $Y=4310
X14 3 5 7 6 pmos1v2hvt_4_CDNS_781539360254 $T=1670 8710 0 180 $X=50 $Y=6310
X15 3 6 7 nmos1v2hvt_4_CDNS_781539360256 $T=1670 775 1 180 $X=50 $Y=55
X16 3 4 2 6 nmos1v2hvt_4_CDNS_781539360259 $T=4450 775 1 180 $X=2830 $Y=55
X17 7 4 1 6 nmos1v2hvt_4_CDNS_781539360259 $T=5690 775 0 0 $X=5070 $Y=55
.ends mux2_1_fL
