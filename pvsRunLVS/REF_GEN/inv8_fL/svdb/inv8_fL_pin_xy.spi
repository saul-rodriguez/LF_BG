* +++++++++++++++++++++++++++++++++++++++++++++++++++++++++ *
* CDL Netlist:                                              *
*                                                           *
* Cell Name  : inv8_fL                                      *
* Netlisted  : Thu Jun 25 17:00:17 2026                     *
* PVS Version: 24.11-s045 Mon Jan 27 22:18:54 PST 2025      *
* +++++++++++++++++++++++++++++++++++++++++++++++++++++++++ *
*.LDD
*.DEVTMPLT 0 MN(nmos1v2hvt) NMOS1V2HVT NDIFF(D) NGATE(G) NDIFF(S) PW1V2(B)
*.DEVTMPLT 1 MP(pmos1v2hvt) PMOS1V2HVT PDIFF(D) PGATE(G) PDIFF(S) NW1V2(B)

* +++++++++++++++++++++++++++++++++++++++++++++++++++++++++ *
* Sub cell: IN2                                             *
* +++++++++++++++++++++++++++++++++++++++++++++++++++++++++ *
.subckt IN2 1 2 3 4
** N=4 EP=4 FDC=2
M0 2 1 4 4 nmos1v2hvt L=1.8e-07 W=6e-07 AD=1.8e-13 AS=1.8e-13 PD=1.2e-06 PS=1.2e-06 m=1 $X=375 $Y=390 $dt=0
M1 2 1 3 3 pmos1v2hvt L=1.8e-07 W=9.4e-07 AD=2.82e-13 AS=2.82e-13 PD=1.54e-06 PS=1.54e-06 m=1 $X=375 $Y=1470 $dt=1
.ends IN2

* +++++++++++++++++++++++++++++++++++++++++++++++++++++++++ *
* Sub cell: inv8_fL                                         *
* +++++++++++++++++++++++++++++++++++++++++++++++++++++++++ *
.subckt inv8_fL 4 1 5 7 9 11 13 15 17 2
+ 6 8 10 12 14 16 18 3
** N=18 EP=18 FDC=16
X0 1 2 3 4 IN2 $T=280 335 0 0 $X=55 $Y=85
X1 5 6 3 4 IN2 $T=1480 335 0 0 $X=1255 $Y=85
X2 7 8 3 4 IN2 $T=2680 335 0 0 $X=2455 $Y=85
X3 9 10 3 4 IN2 $T=3880 335 0 0 $X=3655 $Y=85
X4 11 12 3 4 IN2 $T=5080 335 0 0 $X=4855 $Y=85
X5 13 14 3 4 IN2 $T=6280 335 0 0 $X=6055 $Y=85
X6 15 16 3 4 IN2 $T=7480 335 0 0 $X=7255 $Y=85
X7 17 18 3 4 IN2 $T=8680 335 0 0 $X=8455 $Y=85
.ends inv8_fL
