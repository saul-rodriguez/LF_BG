************************************************************************
* auCdl Netlist:
*
* Library Name:  REF_GEN
* Top Cell Name: REF_GEN_fL_2
* View Name:     schematic
* Netlisted on:  Aug  4 13:22:32 2026
************************************************************************

.INCLUDE  /opt/pdk/lf11/PDK_LF11ISi_V1_3_2/tools/setup/subckt.cdl
*.BIPOLAR
*.RESI = 2000
*.RESVAL
*.CAPVAL
*.DIOPERI
*.DIOAREA
*.EQUATION
*.SCALE METER
*.MEGA
.PARAM

************************************************************************
* Library Name: AnaCommon
* Cell Name:    LS
* View Name:    schematic
************************************************************************

.SUBCKT LS IN OUT VDD VDDD VSS VSSD OUTN
*.PININFO IN:I OUT:O OUTN:O VDD:B VDDD:B VSS:B VSSD:B
MM1 OUT net5 VSS VSS nmos1v2hvt W=260n L=110n m=1 nf=1
MM0 OUTN IN VSS VSS nmos1v2hvt W=260n L=110n m=1 nf=1
MM34 net5 IN VSSD VSSD nmos1v2hvt W=260n L=180n m=1 nf=1
MM3 OUTN OUT VDD VDD pmos1v2hvt W=150n L=1.97u m=1 nf=1
MM2 OUT OUTN VDD VDD pmos1v2hvt W=150n L=1.97u m=1 nf=1
MM36 net5 IN VDDD VDDD pmos1v2hvt W=260n L=180n m=1 nf=1
.ENDS

************************************************************************
* Library Name: REF_GEN
* Cell Name:    LS1
* View Name:    schematic
************************************************************************

.SUBCKT LS1 GNDA GNDD IN0 OUT0 VDDA VDDD
*.PININFO GNDA:B GNDD:B IN0:B OUT0:B VDDA:B VDDD:B
XI0 IN0 OUT0 VDDA VDDD GNDA GNDD net6 / LS
.ENDS

************************************************************************
* Library Name: Si3
* Cell Name:    IN
* View Name:    schematic
************************************************************************

.SUBCKT IN A Out VDD VSS
*.PININFO A:I Out:O VDD:B VSS:B
MM34 Out A VSS VSS nmos1v2hvt W=260n L=180n m=1 nf=1
MM36 Out A VDD VDD pmos1v2hvt W=260n L=180n m=1 nf=1
.ENDS

************************************************************************
* Library Name: Si3
* Cell Name:    NO2
* View Name:    schematic
************************************************************************

.SUBCKT NO2 A B Out VDD VSS
*.PININFO A:I B:I Out:O VDD:B VSS:B
MM39 Out B VSS VSS nmos1v2hvt W=260n L=180n m=1 nf=1
MM34 Out A VSS VSS nmos1v2hvt W=260n L=180n m=1 nf=1
MM37 Out B net5 VDD pmos1v2hvt W=260n L=180n m=1 nf=1
MM36 net5 A VDD VDD pmos1v2hvt W=260n L=180n m=1 nf=1
.ENDS

************************************************************************
* Library Name: Si3
* Cell Name:    NA3
* View Name:    schematic
************************************************************************

.SUBCKT NA3 A B Out VDD VSS C
*.PININFO A:I B:I C:I Out:O VDD:B VSS:B
MM0 Out B net1 VSS nmos1v2hvt W=260n L=180n m=1 nf=1
MM39 net1 C net11 VSS nmos1v2hvt W=260n L=180n m=1 nf=1
MM34 net11 A VSS VSS nmos1v2hvt W=260n L=180n m=1 nf=1
MM1 Out C VDD VDD pmos1v2hvt W=260n L=180n m=1 nf=1
MM37 Out B VDD VDD pmos1v2hvt W=260n L=180n m=1 nf=1
MM36 Out A VDD VDD pmos1v2hvt W=260n L=180n m=1 nf=1
.ENDS

************************************************************************
* Library Name: REF_GEN
* Cell Name:    3to8DeMuxSel
* View Name:    schematic
************************************************************************

.SUBCKT 3to8DeMuxSel A0 A1 A2 D0 D1 D2 D3 D4 D5 D6 D7 S VDD VSS
*.PININFO A0:I A1:I A2:I S:I D0:O D1:O D2:O D3:O D4:O D5:O D6:O D7:O VDD:B
*.PININFO VSS:B
MM498 B0 S VDD VDD pmos1v2hvt W=260n L=180n m=1 nf=1
MM1 B0 A0 VDD VDD pmos1v2hvt W=150n L=110n m=1 nf=1
MM7 B2 A2 VDD VDD pmos1v2hvt W=150n L=110n m=1 nf=1
MM6 B2 S VDD VDD pmos1v2hvt W=260n L=180n m=1 nf=1
MM5 B1 S VDD VDD pmos1v2hvt W=260n L=180n m=1 nf=1
MM4 B1 A1 VDD VDD pmos1v2hvt W=150n L=110n m=1 nf=1
XI19 S SN VDD VSS / IN
XI1 B2 C2 VDD VSS / IN
XI0 B1 C1 VDD VSS / IN
XI10 B0 C0 VDD VSS / IN
XI18 net43 SN D6 VDD VSS / NO2
XI17 net44 SN D7 VDD VSS / NO2
XI16 net42 SN D5 VDD VSS / NO2
XI12 net41 SN D4 VDD VSS / NO2
XI14 net10 SN D2 VDD VSS / NO2
XI15 net2 SN D3 VDD VSS / NO2
XI13 net1 SN D1 VDD VSS / NO2
XI11 net9 SN D0 VDD VSS / NO2
MM9 B2 A2 net47 VSS nmos1v2hvt W=150n L=110n m=1 nf=1
MM8 net47 S VSS VSS nmos1v2hvt W=150n L=180n m=1 nf=1
MM3 net46 S VSS VSS nmos1v2hvt W=150n L=180n m=1 nf=1
MM2 B1 A1 net46 VSS nmos1v2hvt W=150n L=110n m=1 nf=1
MM0 net45 S VSS VSS nmos1v2hvt W=150n L=180n m=1 nf=1
MM497 B0 A0 net45 VSS nmos1v2hvt W=150n L=110n m=1 nf=1
XI9 C2 C1 net44 VDD VSS C0 / NA3
XI8 B0 C1 net43 VDD VSS C2 / NA3
XI7 C0 B1 net42 VDD VSS C2 / NA3
XI6 C2 B0 net41 VDD VSS B1 / NA3
XI5 B2 C1 net2 VDD VSS C0 / NA3
XI4 C1 B0 net10 VDD VSS B2 / NA3
XI3 B1 C0 net1 VDD VSS B2 / NA3
XI2 B2 B1 net9 VDD VSS B0 / NA3
.ENDS

************************************************************************
* Library Name: lf11is
* Cell Name:    rnpolyh_pcell_0
* View Name:    schematic
************************************************************************

.SUBCKT rnpolyh_pcell_0 B MINUS PLUS w=500n l=2u m=1
*.PININFO B:B MINUS:B PLUS:B
RR_1_0 PLUS MINUS $SUB=B $[rnpolyh] $W=w $L=l
RR_0_0 PLUS MINUS $SUB=B $[rnpolyh] $W=w $L=l
.ENDS

************************************************************************
* Library Name: lf11is
* Cell Name:    rnpolyh_pcell_1
* View Name:    schematic
************************************************************************

.SUBCKT rnpolyh_pcell_1 B MINUS PLUS w=500n l=2u m=1
*.PININFO B:B MINUS:B PLUS:B
RR_0_0 PLUS MINUS $SUB=B $[rnpolyh] $W=w $L=l
.ENDS

************************************************************************
* Library Name: lf11is
* Cell Name:    rnpolyh_pcell_2
* View Name:    schematic
************************************************************************

.SUBCKT rnpolyh_pcell_2 B MINUS PLUS w=500n l=2u m=1
*.PININFO B:B MINUS:B PLUS:B
RR_0_85 MINUS int_0_85 $SUB=B $[rnpolyh] $W=w $L=l
RR_0_84 int_0_84 int_0_85 $SUB=B $[rnpolyh] $W=w $L=l
RR_0_83 int_0_84 int_0_83 $SUB=B $[rnpolyh] $W=w $L=l
RR_0_82 int_0_82 int_0_83 $SUB=B $[rnpolyh] $W=w $L=l
RR_0_81 int_0_82 int_0_81 $SUB=B $[rnpolyh] $W=w $L=l
RR_0_80 int_0_80 int_0_81 $SUB=B $[rnpolyh] $W=w $L=l
RR_0_79 int_0_80 int_0_79 $SUB=B $[rnpolyh] $W=w $L=l
RR_0_78 int_0_78 int_0_79 $SUB=B $[rnpolyh] $W=w $L=l
RR_0_77 int_0_78 int_0_77 $SUB=B $[rnpolyh] $W=w $L=l
RR_0_76 int_0_76 int_0_77 $SUB=B $[rnpolyh] $W=w $L=l
RR_0_75 int_0_76 int_0_75 $SUB=B $[rnpolyh] $W=w $L=l
RR_0_74 int_0_74 int_0_75 $SUB=B $[rnpolyh] $W=w $L=l
RR_0_73 int_0_74 int_0_73 $SUB=B $[rnpolyh] $W=w $L=l
RR_0_72 int_0_72 int_0_73 $SUB=B $[rnpolyh] $W=w $L=l
RR_0_71 int_0_72 int_0_71 $SUB=B $[rnpolyh] $W=w $L=l
RR_0_70 int_0_70 int_0_71 $SUB=B $[rnpolyh] $W=w $L=l
RR_0_69 int_0_70 int_0_69 $SUB=B $[rnpolyh] $W=w $L=l
RR_0_68 int_0_68 int_0_69 $SUB=B $[rnpolyh] $W=w $L=l
RR_0_67 int_0_68 int_0_67 $SUB=B $[rnpolyh] $W=w $L=l
RR_0_66 int_0_66 int_0_67 $SUB=B $[rnpolyh] $W=w $L=l
RR_0_65 int_0_66 int_0_65 $SUB=B $[rnpolyh] $W=w $L=l
RR_0_64 int_0_64 int_0_65 $SUB=B $[rnpolyh] $W=w $L=l
RR_0_63 int_0_64 int_0_63 $SUB=B $[rnpolyh] $W=w $L=l
RR_0_62 int_0_62 int_0_63 $SUB=B $[rnpolyh] $W=w $L=l
RR_0_61 int_0_62 int_0_61 $SUB=B $[rnpolyh] $W=w $L=l
RR_0_60 int_0_60 int_0_61 $SUB=B $[rnpolyh] $W=w $L=l
RR_0_59 int_0_60 int_0_59 $SUB=B $[rnpolyh] $W=w $L=l
RR_0_58 int_0_58 int_0_59 $SUB=B $[rnpolyh] $W=w $L=l
RR_0_57 int_0_58 int_0_57 $SUB=B $[rnpolyh] $W=w $L=l
RR_0_56 int_0_56 int_0_57 $SUB=B $[rnpolyh] $W=w $L=l
RR_0_55 int_0_56 int_0_55 $SUB=B $[rnpolyh] $W=w $L=l
RR_0_54 int_0_54 int_0_55 $SUB=B $[rnpolyh] $W=w $L=l
RR_0_53 int_0_54 int_0_53 $SUB=B $[rnpolyh] $W=w $L=l
RR_0_52 int_0_52 int_0_53 $SUB=B $[rnpolyh] $W=w $L=l
RR_0_51 int_0_52 int_0_51 $SUB=B $[rnpolyh] $W=w $L=l
RR_0_50 int_0_50 int_0_51 $SUB=B $[rnpolyh] $W=w $L=l
RR_0_49 int_0_50 int_0_49 $SUB=B $[rnpolyh] $W=w $L=l
RR_0_48 int_0_48 int_0_49 $SUB=B $[rnpolyh] $W=w $L=l
RR_0_47 int_0_48 int_0_47 $SUB=B $[rnpolyh] $W=w $L=l
RR_0_46 int_0_46 int_0_47 $SUB=B $[rnpolyh] $W=w $L=l
RR_0_45 int_0_46 int_0_45 $SUB=B $[rnpolyh] $W=w $L=l
RR_0_44 int_0_44 int_0_45 $SUB=B $[rnpolyh] $W=w $L=l
RR_0_43 int_0_44 int_0_43 $SUB=B $[rnpolyh] $W=w $L=l
RR_0_42 int_0_42 int_0_43 $SUB=B $[rnpolyh] $W=w $L=l
RR_0_41 int_0_42 int_0_41 $SUB=B $[rnpolyh] $W=w $L=l
RR_0_40 int_0_40 int_0_41 $SUB=B $[rnpolyh] $W=w $L=l
RR_0_39 int_0_40 int_0_39 $SUB=B $[rnpolyh] $W=w $L=l
RR_0_38 int_0_38 int_0_39 $SUB=B $[rnpolyh] $W=w $L=l
RR_0_37 int_0_38 int_0_37 $SUB=B $[rnpolyh] $W=w $L=l
RR_0_36 int_0_36 int_0_37 $SUB=B $[rnpolyh] $W=w $L=l
RR_0_35 int_0_36 int_0_35 $SUB=B $[rnpolyh] $W=w $L=l
RR_0_34 int_0_34 int_0_35 $SUB=B $[rnpolyh] $W=w $L=l
RR_0_33 int_0_34 int_0_33 $SUB=B $[rnpolyh] $W=w $L=l
RR_0_32 int_0_32 int_0_33 $SUB=B $[rnpolyh] $W=w $L=l
RR_0_31 int_0_32 int_0_31 $SUB=B $[rnpolyh] $W=w $L=l
RR_0_30 int_0_30 int_0_31 $SUB=B $[rnpolyh] $W=w $L=l
RR_0_29 int_0_30 int_0_29 $SUB=B $[rnpolyh] $W=w $L=l
RR_0_28 int_0_28 int_0_29 $SUB=B $[rnpolyh] $W=w $L=l
RR_0_27 int_0_28 int_0_27 $SUB=B $[rnpolyh] $W=w $L=l
RR_0_26 int_0_26 int_0_27 $SUB=B $[rnpolyh] $W=w $L=l
RR_0_25 int_0_26 int_0_25 $SUB=B $[rnpolyh] $W=w $L=l
RR_0_24 int_0_24 int_0_25 $SUB=B $[rnpolyh] $W=w $L=l
RR_0_23 int_0_24 int_0_23 $SUB=B $[rnpolyh] $W=w $L=l
RR_0_22 int_0_22 int_0_23 $SUB=B $[rnpolyh] $W=w $L=l
RR_0_21 int_0_22 int_0_21 $SUB=B $[rnpolyh] $W=w $L=l
RR_0_20 int_0_20 int_0_21 $SUB=B $[rnpolyh] $W=w $L=l
RR_0_19 int_0_20 int_0_19 $SUB=B $[rnpolyh] $W=w $L=l
RR_0_18 int_0_18 int_0_19 $SUB=B $[rnpolyh] $W=w $L=l
RR_0_17 int_0_18 int_0_17 $SUB=B $[rnpolyh] $W=w $L=l
RR_0_16 int_0_16 int_0_17 $SUB=B $[rnpolyh] $W=w $L=l
RR_0_15 int_0_16 int_0_15 $SUB=B $[rnpolyh] $W=w $L=l
RR_0_14 int_0_14 int_0_15 $SUB=B $[rnpolyh] $W=w $L=l
RR_0_13 int_0_14 int_0_13 $SUB=B $[rnpolyh] $W=w $L=l
RR_0_12 int_0_12 int_0_13 $SUB=B $[rnpolyh] $W=w $L=l
RR_0_11 int_0_12 int_0_11 $SUB=B $[rnpolyh] $W=w $L=l
RR_0_10 int_0_10 int_0_11 $SUB=B $[rnpolyh] $W=w $L=l
RR_0_9 int_0_10 int_0_9 $SUB=B $[rnpolyh] $W=w $L=l
RR_0_8 int_0_8 int_0_9 $SUB=B $[rnpolyh] $W=w $L=l
RR_0_7 int_0_8 int_0_7 $SUB=B $[rnpolyh] $W=w $L=l
RR_0_6 int_0_6 int_0_7 $SUB=B $[rnpolyh] $W=w $L=l
RR_0_5 int_0_6 int_0_5 $SUB=B $[rnpolyh] $W=w $L=l
RR_0_4 int_0_4 int_0_5 $SUB=B $[rnpolyh] $W=w $L=l
RR_0_3 int_0_4 int_0_3 $SUB=B $[rnpolyh] $W=w $L=l
RR_0_2 int_0_2 int_0_3 $SUB=B $[rnpolyh] $W=w $L=l
RR_0_1 int_0_2 int_0_1 $SUB=B $[rnpolyh] $W=w $L=l
RR_0_0 PLUS int_0_1 $SUB=B $[rnpolyh] $W=w $L=l
.ENDS

************************************************************************
* Library Name: REF_GEN
* Cell Name:    trim_res_bg_sl_fL
* View Name:    schematic
************************************************************************

.SUBCKT trim_res_bg_sl_fL P1 P2 REF S0 S1 S2 S3 S4 S5 S6 S7
*.PININFO P1:B P2:B REF:B S0:B S1:B S2:B S3:B S4:B S5:B S6:B S7:B
XR13 REF REF REF / rnpolyh_pcell_0 l=10u w=500n m=2
XR10 REF S0 net1 / rnpolyh_pcell_1 l=10u w=500n m=1
XR12 REF net1 P1 / rnpolyh_pcell_2 l=10u w=500n m=1
XR8 REF S7 S6 / rnpolyh_pcell_1 l=10u w=500n m=1
XR7 REF S6 S5 / rnpolyh_pcell_1 l=10u w=500n m=1
XR6 REF S5 S4 / rnpolyh_pcell_1 l=10u w=500n m=1
XR5 REF S4 S3 / rnpolyh_pcell_1 l=10u w=500n m=1
XR3 REF S2 S1 / rnpolyh_pcell_1 l=10u w=500n m=1
XR2 REF S1 S0 / rnpolyh_pcell_1 l=10u w=500n m=1
XR11 REF P2 S7 / rnpolyh_pcell_1 l=10u w=500n m=1
XR4 REF S3 S2 / rnpolyh_pcell_1 l=10u w=500n m=1
.ENDS

************************************************************************
* Library Name: REF_GEN
* Cell Name:    BG_PNP_array
* View Name:    schematic
************************************************************************

.SUBCKT BG_PNP_array A B GNDA
*.PININFO A:B B:B GNDA:B
QQ3 GNDA GNDA GNDA pnp5ux5u M=3 AE=25p
QQ2 GNDA GNDA GNDA pnp5ux5u M=7 AE=25p
QQ1 GNDA GNDA B pnp5ux5u M=255 AE=25p
QQ0 GNDA GNDA A pnp5ux5u M=1 AE=25p
.ENDS

************************************************************************
* Library Name: REF_GEN
* Cell Name:    mux8_1_fL
* View Name:    schematic
************************************************************************

.SUBCKT mux8_1_fL A0 A1 A2 A3 A4 A5 A6 A7 COM GNDA IN0 IN1 IN2 IN3 IN4 IN5 IN6
+ IN7
*.PININFO A0:B A1:B A2:B A3:B A4:B A5:B A6:B A7:B COM:B GNDA:B IN0:B IN1:B
*.PININFO IN2:B IN3:B IN4:B IN5:B IN6:B IN7:B
MM6 IN5 A5 COM GNDA nmos1v2hvt W=10u L=1u m=1 nf=1
MM5 IN4 A4 COM GNDA nmos1v2hvt W=10u L=1u m=1 nf=1
MM4 IN7 A7 COM GNDA nmos1v2hvt W=10u L=1u m=1 nf=1
MM3 IN6 A6 COM GNDA nmos1v2hvt W=10u L=1u m=1 nf=1
MM2 IN1 A1 COM GNDA nmos1v2hvt W=10u L=1u m=1 nf=1
MM1 IN0 A0 COM GNDA nmos1v2hvt W=10u L=1u m=1 nf=1
MM0 IN3 A3 COM GNDA nmos1v2hvt W=10u L=1u m=1 nf=1
MM7 IN2 A2 COM GNDA nmos1v2hvt W=10u L=1u m=1 nf=1
.ENDS

************************************************************************
* Library Name: lf11is
* Cell Name:    rnpolyh_pcell_3
* View Name:    schematic
************************************************************************

.SUBCKT rnpolyh_pcell_3 B MINUS PLUS w=500n l=2u m=1
*.PININFO B:B MINUS:B PLUS:B
RR_0_24 int_0_24 MINUS $SUB=B $[rnpolyh] $W=w $L=l
RR_0_23 int_0_24 int_0_23 $SUB=B $[rnpolyh] $W=w $L=l
RR_0_22 int_0_22 int_0_23 $SUB=B $[rnpolyh] $W=w $L=l
RR_0_21 int_0_22 int_0_21 $SUB=B $[rnpolyh] $W=w $L=l
RR_0_20 int_0_20 int_0_21 $SUB=B $[rnpolyh] $W=w $L=l
RR_0_19 int_0_20 int_0_19 $SUB=B $[rnpolyh] $W=w $L=l
RR_0_18 int_0_18 int_0_19 $SUB=B $[rnpolyh] $W=w $L=l
RR_0_17 int_0_18 int_0_17 $SUB=B $[rnpolyh] $W=w $L=l
RR_0_16 int_0_16 int_0_17 $SUB=B $[rnpolyh] $W=w $L=l
RR_0_15 int_0_16 int_0_15 $SUB=B $[rnpolyh] $W=w $L=l
RR_0_14 int_0_14 int_0_15 $SUB=B $[rnpolyh] $W=w $L=l
RR_0_13 int_0_14 int_0_13 $SUB=B $[rnpolyh] $W=w $L=l
RR_0_12 int_0_12 int_0_13 $SUB=B $[rnpolyh] $W=w $L=l
RR_0_11 int_0_12 int_0_11 $SUB=B $[rnpolyh] $W=w $L=l
RR_0_10 int_0_10 int_0_11 $SUB=B $[rnpolyh] $W=w $L=l
RR_0_9 int_0_10 int_0_9 $SUB=B $[rnpolyh] $W=w $L=l
RR_0_8 int_0_8 int_0_9 $SUB=B $[rnpolyh] $W=w $L=l
RR_0_7 int_0_8 int_0_7 $SUB=B $[rnpolyh] $W=w $L=l
RR_0_6 int_0_6 int_0_7 $SUB=B $[rnpolyh] $W=w $L=l
RR_0_5 int_0_6 int_0_5 $SUB=B $[rnpolyh] $W=w $L=l
RR_0_4 int_0_4 int_0_5 $SUB=B $[rnpolyh] $W=w $L=l
RR_0_3 int_0_4 int_0_3 $SUB=B $[rnpolyh] $W=w $L=l
RR_0_2 int_0_2 int_0_3 $SUB=B $[rnpolyh] $W=w $L=l
RR_0_1 int_0_2 int_0_1 $SUB=B $[rnpolyh] $W=w $L=l
RR_0_0 PLUS int_0_1 $SUB=B $[rnpolyh] $W=w $L=l
.ENDS

************************************************************************
* Library Name: REF_GEN
* Cell Name:    BG_STARTUP_fL2
* View Name:    schematic
************************************************************************

.SUBCKT BG_STARTUP_fL2 BIAS GNDA PD PDN PRN PRN_TRIGGER VDDA VREF
*.PININFO BIAS:B GNDA:B PD:B PDN:B PRN:B PRN_TRIGGER:B VDDA:B VREF:B
MM27 net6 net6 STARTUP_REF GNDA nmos1v2hvt W=1u L=10u m=1 nf=1
MM25 PRN_TRIGGER net26 GNDA GNDA nmos1v2hvt W=4u L=4u m=1 nf=1
MM24 net26 net26 GNDA GNDA nmos1v2hvt W=4u L=4u m=1 nf=1
MM26 STARTUP_REF STARTUP_REF GNDA GNDA nmos1v2hvt W=1u L=10u m=1 nf=1
MM44 PRN_TRIGGER PD GNDA GNDA nmos1v2hvt W=1u L=500n m=1 nf=1
MM37 net26 PD GNDA GNDA nmos1v2hvt W=1u L=500n m=1 nf=1
MM49 PRN net8 GNDA GNDA nmos1v2hvt W=1u L=200n m=1 nf=1
MM47 net8 net7 GNDA GNDA nmos1v2hvt W=1u L=200n m=1 nf=1
MM45 net7 PRN_TRIGGER GNDA GNDA nmos1v2hvt W=4u L=200n m=1 nf=2
MM1 VDDA VDDA VDDA VDDA pmos1v2hvt W=8u L=1u m=2 nf=1
MM0 VDDA VDDA VDDA VDDA pmos1v2hvt W=8u L=500n m=4 nf=1
MM38 BIAS PDN VDDA VDDA pmos1v2hvt W=2u L=500n m=1 nf=1
MM35 net6 BIAS VDDA VDDA pmos1v2hvt W=8u L=4u m=1 nf=1
MM23 BIAS BIAS VDDA VDDA pmos1v2hvt W=8u L=4u m=2 nf=1
MM21 net25 BIAS VDDA VDDA pmos1v2hvt W=8u L=4u m=2 nf=1
MM20 net26 STARTUP_REF net25 VDDA pmos1v2hvt W=8u L=2u m=10 nf=1
MM19 PRN_TRIGGER VREF net25 VDDA pmos1v2hvt W=8u L=2u m=10 nf=1
MM50 PRN net8 VDDA VDDA pmos1v2hvt W=2u L=200n m=1 nf=1
MM48 net8 net7 VDDA VDDA pmos1v2hvt W=2u L=200n m=1 nf=1
MM46 net7 PRN_TRIGGER VDDA VDDA pmos1v2hvt W=2u L=500n m=1 nf=1
.ENDS

************************************************************************
* Library Name: lf11is
* Cell Name:    rnpolyh_pcell_4
* View Name:    schematic
************************************************************************

.SUBCKT rnpolyh_pcell_4 B MINUS PLUS w=500n l=2u m=1
*.PININFO B:B MINUS:B PLUS:B
RR_0_43 MINUS int_0_43 $SUB=B $[rnpolyh] $W=w $L=l
RR_0_42 int_0_42 int_0_43 $SUB=B $[rnpolyh] $W=w $L=l
RR_0_41 int_0_42 int_0_41 $SUB=B $[rnpolyh] $W=w $L=l
RR_0_40 int_0_40 int_0_41 $SUB=B $[rnpolyh] $W=w $L=l
RR_0_39 int_0_40 int_0_39 $SUB=B $[rnpolyh] $W=w $L=l
RR_0_38 int_0_38 int_0_39 $SUB=B $[rnpolyh] $W=w $L=l
RR_0_37 int_0_38 int_0_37 $SUB=B $[rnpolyh] $W=w $L=l
RR_0_36 int_0_36 int_0_37 $SUB=B $[rnpolyh] $W=w $L=l
RR_0_35 int_0_36 int_0_35 $SUB=B $[rnpolyh] $W=w $L=l
RR_0_34 int_0_34 int_0_35 $SUB=B $[rnpolyh] $W=w $L=l
RR_0_33 int_0_34 int_0_33 $SUB=B $[rnpolyh] $W=w $L=l
RR_0_32 int_0_32 int_0_33 $SUB=B $[rnpolyh] $W=w $L=l
RR_0_31 int_0_32 int_0_31 $SUB=B $[rnpolyh] $W=w $L=l
RR_0_30 int_0_30 int_0_31 $SUB=B $[rnpolyh] $W=w $L=l
RR_0_29 int_0_30 int_0_29 $SUB=B $[rnpolyh] $W=w $L=l
RR_0_28 int_0_28 int_0_29 $SUB=B $[rnpolyh] $W=w $L=l
RR_0_27 int_0_28 int_0_27 $SUB=B $[rnpolyh] $W=w $L=l
RR_0_26 int_0_26 int_0_27 $SUB=B $[rnpolyh] $W=w $L=l
RR_0_25 int_0_26 int_0_25 $SUB=B $[rnpolyh] $W=w $L=l
RR_0_24 int_0_24 int_0_25 $SUB=B $[rnpolyh] $W=w $L=l
RR_0_23 int_0_24 int_0_23 $SUB=B $[rnpolyh] $W=w $L=l
RR_0_22 int_0_22 int_0_23 $SUB=B $[rnpolyh] $W=w $L=l
RR_0_21 int_0_22 int_0_21 $SUB=B $[rnpolyh] $W=w $L=l
RR_0_20 int_0_20 int_0_21 $SUB=B $[rnpolyh] $W=w $L=l
RR_0_19 int_0_20 int_0_19 $SUB=B $[rnpolyh] $W=w $L=l
RR_0_18 int_0_18 int_0_19 $SUB=B $[rnpolyh] $W=w $L=l
RR_0_17 int_0_18 int_0_17 $SUB=B $[rnpolyh] $W=w $L=l
RR_0_16 int_0_16 int_0_17 $SUB=B $[rnpolyh] $W=w $L=l
RR_0_15 int_0_16 int_0_15 $SUB=B $[rnpolyh] $W=w $L=l
RR_0_14 int_0_14 int_0_15 $SUB=B $[rnpolyh] $W=w $L=l
RR_0_13 int_0_14 int_0_13 $SUB=B $[rnpolyh] $W=w $L=l
RR_0_12 int_0_12 int_0_13 $SUB=B $[rnpolyh] $W=w $L=l
RR_0_11 int_0_12 int_0_11 $SUB=B $[rnpolyh] $W=w $L=l
RR_0_10 int_0_10 int_0_11 $SUB=B $[rnpolyh] $W=w $L=l
RR_0_9 int_0_10 int_0_9 $SUB=B $[rnpolyh] $W=w $L=l
RR_0_8 int_0_8 int_0_9 $SUB=B $[rnpolyh] $W=w $L=l
RR_0_7 int_0_8 int_0_7 $SUB=B $[rnpolyh] $W=w $L=l
RR_0_6 int_0_6 int_0_7 $SUB=B $[rnpolyh] $W=w $L=l
RR_0_5 int_0_6 int_0_5 $SUB=B $[rnpolyh] $W=w $L=l
RR_0_4 int_0_4 int_0_5 $SUB=B $[rnpolyh] $W=w $L=l
RR_0_3 int_0_4 int_0_3 $SUB=B $[rnpolyh] $W=w $L=l
RR_0_2 int_0_2 int_0_3 $SUB=B $[rnpolyh] $W=w $L=l
RR_0_1 int_0_2 int_0_1 $SUB=B $[rnpolyh] $W=w $L=l
RR_0_0 PLUS int_0_1 $SUB=B $[rnpolyh] $W=w $L=l
.ENDS

************************************************************************
* Library Name: lf11is
* Cell Name:    rnpolyh_pcell_5
* View Name:    schematic
************************************************************************

.SUBCKT rnpolyh_pcell_5 B MINUS PLUS w=500n l=2u m=1
*.PININFO B:B MINUS:B PLUS:B
RR_0_1 PLUS MINUS $SUB=B $[rnpolyh] $W=w $L=l
RR_0_0 PLUS MINUS $SUB=B $[rnpolyh] $W=w $L=l
.ENDS

************************************************************************
* Library Name: lf11is
* Cell Name:    rnpolyh_pcell_6
* View Name:    schematic
************************************************************************

.SUBCKT rnpolyh_pcell_6 B MINUS PLUS w=500n l=2u m=1
*.PININFO B:B MINUS:B PLUS:B
RR_0_4 PLUS MINUS $SUB=B $[rnpolyh] $W=w $L=l
RR_0_3 PLUS MINUS $SUB=B $[rnpolyh] $W=w $L=l
RR_0_2 PLUS MINUS $SUB=B $[rnpolyh] $W=w $L=l
RR_0_1 PLUS MINUS $SUB=B $[rnpolyh] $W=w $L=l
RR_0_0 PLUS MINUS $SUB=B $[rnpolyh] $W=w $L=l
.ENDS

************************************************************************
* Library Name: REF_GEN
* Cell Name:    trim_res_bg_2_fL
* View Name:    schematic
************************************************************************

.SUBCKT trim_res_bg_2_fL P1 P2 REF S0 S1 S2 S3 S4 S5 S6 S7
*.PININFO P1:B P2:B REF:B S0:B S1:B S2:B S3:B S4:B S5:B S6:B S7:B
XR12<0> REF REF REF / rnpolyh_pcell_1 l=10u w=500n m=1
XR12<1> REF REF REF / rnpolyh_pcell_1 l=10u w=500n m=1
XR12<2> REF REF REF / rnpolyh_pcell_1 l=10u w=500n m=1
XR12<3> REF REF REF / rnpolyh_pcell_1 l=10u w=500n m=1
XR12<4> REF REF REF / rnpolyh_pcell_1 l=10u w=500n m=1
XR12<5> REF REF REF / rnpolyh_pcell_1 l=10u w=500n m=1
XR12<6> REF REF REF / rnpolyh_pcell_1 l=10u w=500n m=1
XR11 REF net2 P1 / rnpolyh_pcell_4 l=10u w=500n m=1
XR10 REF net1 net2 / rnpolyh_pcell_5 l=10u w=500n m=1
XR9 REF P2 S7 / rnpolyh_pcell_6 l=10u w=500n m=1
XR8 REF S7 S6 / rnpolyh_pcell_6 l=10u w=500n m=1
XR7 REF S6 S5 / rnpolyh_pcell_6 l=10u w=500n m=1
XR6 REF S5 S4 / rnpolyh_pcell_6 l=10u w=500n m=1
XR5 REF S4 S3 / rnpolyh_pcell_6 l=10u w=500n m=1
XR3 REF S2 S1 / rnpolyh_pcell_6 l=10u w=500n m=1
XR2 REF S1 S0 / rnpolyh_pcell_6 l=10u w=500n m=1
XR1 REF S0 net11 / rnpolyh_pcell_6 l=10u w=500n m=1
XR0 REF net11 net1 / rnpolyh_pcell_5 l=10u w=500n m=1
XR4 REF S3 S2 / rnpolyh_pcell_6 l=10u w=500n m=1
.ENDS

************************************************************************
* Library Name: REF_GEN
* Cell Name:    BG_TRIM_4_fL
* View Name:    schematic
************************************************************************

.SUBCKT BG_TRIM_4_fL BIAS EN GNDA PRN TRIM_OUT<0> TRIM_OUT<1> TRIM_OUT<2>
+ TRIM_OUT<3> TRIM_OUT<4> TRIM_OUT<5> TRIM_OUT<6> TRIM_OUT<7> TRIM_SL<0>
+ TRIM_SL<1> TRIM_SL<2> TRIM_SL<3> TRIM_SL<4> TRIM_SL<5> TRIM_SL<6> TRIM_SL<7>
+ VDDA VREF
*.PININFO BIAS:B EN:B GNDA:B PRN:B TRIM_OUT<0>:B TRIM_OUT<1>:B TRIM_OUT<2>:B
*.PININFO TRIM_OUT<3>:B TRIM_OUT<4>:B TRIM_OUT<5>:B TRIM_OUT<6>:B
*.PININFO TRIM_OUT<7>:B TRIM_SL<0>:B TRIM_SL<1>:B TRIM_SL<2>:B TRIM_SL<3>:B
*.PININFO TRIM_SL<4>:B TRIM_SL<5>:B TRIM_SL<6>:B TRIM_SL<7>:B VDDA:B VREF:B
XI8 X GNDA GNDA net53 net52 net54 net55 net56 net57 net36 net48 /
+ trim_res_bg_sl_fL
XI5 Y GNDA GNDA net29 net30 net31 net32 net33 net34 net27 net28 /
+ trim_res_bg_sl_fL
MM51 VDDA VDDA VDDA VDDA pmos1v2hvt W=40u L=1u m=4 nf=1
MM53 VDDA VDDA VDDA VDDA pmos1v2hvt W=1u L=10u m=16 nf=1
MM43 net20 net20 net37 VDDA pmos1v2hvt W=5u L=500n m=1 nf=1
MM41 net37 net37 VDDA VDDA pmos1v2hvt W=5u L=500n m=1 nf=1
MM40 PD EN VDDA VDDA pmos1v2hvt W=2u L=500n m=1 nf=1
MM85 P PDN VDDA VDDA pmos1v2hvt W=560n L=2u m=1 nf=1
MM82 PDN PD VDDA VDDA pmos1v2hvt W=2u L=500n m=1 nf=1
MM34 net11 P net3 VDDA pmos1v2hvt W=40u L=10u m=10 nf=1
MM33 net3 P VDDA VDDA pmos1v2hvt W=40u L=10u m=10 nf=1
MM32 net10 P VDDA VDDA pmos1v2hvt W=40u L=10u m=10 nf=1
MM10 P net6 VDDA VDDA pmos1v2hvt W=40u L=7.5u m=8 nf=1
MM9 net6 net6 VDDA VDDA pmos1v2hvt W=40u L=7.5u m=8 nf=1
MM5 VREF net20 net4 VDDA pmos1v2hvt W=40u L=500n m=1 nf=10
MM4 Y net20 net2 VDDA pmos1v2hvt W=40u L=500n m=1 nf=10
MM31 net2 P net10 VDDA pmos1v2hvt W=40u L=10u m=10 nf=1
MM30 net4 P net14 VDDA pmos1v2hvt W=40u L=10u m=10 nf=1
MM3 X net20 net11 VDDA pmos1v2hvt W=40u L=500n m=1 nf=10
MM29 net14 P VDDA VDDA pmos1v2hvt W=40u L=10u m=10 nf=1
MM52 VDDA VDDA VDDA VDDA pmos1v2hvt W=40u L=10u m=4 nf=1
XI10 X net1 GNDA / BG_PNP_array
MM54 GNDA GNDA GNDA GNDA nmos1v2hvt W=4u L=4u m=5 nf=1
MM42 net20 net16 GNDA GNDA nmos1v2hvt W=4u L=4u m=1 nf=1
MM39 PD EN GNDA GNDA nmos1v2hvt W=1u L=500n m=1 nf=1
MM83 BIAS PDN net16 GNDA nmos1v2hvt W=1u L=500n m=1 nf=1
MM84 net16 PD GNDA GNDA nmos1v2hvt W=1u L=500n m=1 nf=1
MM81 PDN PD GNDA GNDA nmos1v2hvt W=1u L=500n m=1 nf=1
MM18 P PRN_TRIGGER net12 GNDA nmos1v2hvt W=2u L=110n m=1 nf=1
MM17 net12 net16 GNDA GNDA nmos1v2hvt W=4u L=4u m=1 nf=1
MM22 net8 net16 GNDA GNDA nmos1v2hvt W=4u L=4u m=1 nf=1
MM8 net7 net16 GNDA GNDA nmos1v2hvt W=4u L=4u m=4 nf=1
MM7 net6 Y net7 GNDA nmos1v2hvt W=20u L=2u m=30 nf=1
MM11 net16 net16 GNDA GNDA nmos1v2hvt W=4u L=4u m=4 nf=1
MM6 P X net7 GNDA nmos1v2hvt W=20u L=2u m=30 nf=1
MM50 GNDA GNDA GNDA GNDA nmos1v2hvt W=20u L=2u m=4 nf=1
XI7 TRIM_SL<0> TRIM_SL<1> TRIM_SL<2> TRIM_SL<3> TRIM_SL<4> TRIM_SL<5>
+ TRIM_SL<6> TRIM_SL<7> GNDA GNDA net53 net52 net54 net55 net56 net57 net36
+ net48 / mux8_1_fL
XI6 TRIM_SL<0> TRIM_SL<1> TRIM_SL<2> TRIM_SL<3> TRIM_SL<4> TRIM_SL<5>
+ TRIM_SL<6> TRIM_SL<7> GNDA GNDA net29 net30 net31 net32 net33 net34 net27
+ net28 / mux8_1_fL
XI3 TRIM_OUT<0> TRIM_OUT<1> TRIM_OUT<2> TRIM_OUT<3> TRIM_OUT<4> TRIM_OUT<5>
+ TRIM_OUT<6> TRIM_OUT<7> GNDA GNDA net9 net18 net21 net22 net23 net24 net25
+ net26 / mux8_1_fL
XR11 GNDA GNDA GNDA / rnpolyh_pcell_0 l=10u w=500n m=2
XR1 GNDA net1 Y / rnpolyh_pcell_3 l=10u w=500n m=1
CC1 VREF GNDA (70u)*(9u) $[cmims2] M=10 A=6.3e-10 P=0.000158
XI9 net8 GNDA PD PDN PRN PRN_TRIGGER VDDA VREF / BG_STARTUP_fL2
XI4 VREF GNDA GNDA net9 net18 net21 net22 net23 net24 net25 net26 /
+ trim_res_bg_2_fL
.ENDS

************************************************************************
* Library Name: AnaCommon
* Cell Name:    Tsw
* View Name:    schematic
************************************************************************

.SUBCKT Tsw In Out S VDD VSS
*.PININFO In:I S:I Out:O VDD:B VSS:B
MM9 net3 SN net4 VSS nmos1v2hvt W=150n L=1.265u m=1 nf=1
MM8 net4 SN VSS VSS nmos1v2hvt W=150n L=1.265u m=1 nf=1
MM6 net3 S Out VSS nmos1v2hvt W=260n L=200n m=1 nf=1
MM4 In S net3 VSS nmos1v2hvt W=260n L=200n m=1 nf=1
MM2 SN S VSS VSS nmos1v2hvt W=260n L=180n m=1 nf=1
MM7 net3 SN Out VDD pmos1v2hvt W=770n L=200n m=1 nf=1
MM5 In SN net3 VDD pmos1v2hvt W=770n L=200n m=1 nf=1
MM3 SN S VDD VDD pmos1v2hvt W=260n L=180n m=1 nf=1
.ENDS

************************************************************************
* Library Name: REF_GEN
* Cell Name:    mux8_1p_fL
* View Name:    schematic
************************************************************************

.SUBCKT mux8_1p_fL A0 A1 A2 A3 A4 A5 A6 A7 COM IN0 IN1 IN2 IN3 IN4 IN5 IN6 IN7
+ VDDA
*.PININFO A0:B A1:B A2:B A3:B A4:B A5:B A6:B A7:B COM:B IN0:B IN1:B IN2:B
*.PININFO IN3:B IN4:B IN5:B IN6:B IN7:B VDDA:B
MM6 COM A5 IN5 VDDA pmos1v2hvt W=10u L=1u m=1 nf=1
MM5 COM A4 IN4 VDDA pmos1v2hvt W=10u L=1u m=1 nf=1
MM4 COM A7 IN7 VDDA pmos1v2hvt W=10u L=1u m=1 nf=1
MM3 COM A6 IN6 VDDA pmos1v2hvt W=10u L=1u m=1 nf=1
MM2 COM A1 IN1 VDDA pmos1v2hvt W=10u L=1u m=1 nf=1
MM1 COM A0 IN0 VDDA pmos1v2hvt W=10u L=1u m=1 nf=1
MM0 COM A3 IN3 VDDA pmos1v2hvt W=10u L=1u m=1 nf=1
MM7 COM A2 IN2 VDDA pmos1v2hvt W=10u L=1u m=1 nf=1
.ENDS

************************************************************************
* Library Name: Si3
* Cell Name:    IN2
* View Name:    schematic
************************************************************************

.SUBCKT IN2 A Out VDD VSS
*.PININFO A:I Out:O VDD:B VSS:B
MM34 Out A VSS VSS nmos1v2hvt W=600n L=180n m=1 nf=1
MM36 Out A VDD VDD pmos1v2hvt W=940n L=180n m=1 nf=1
.ENDS

************************************************************************
* Library Name: REF_GEN
* Cell Name:    inv8_fL
* View Name:    schematic
************************************************************************

.SUBCKT inv8_fL GNDA IN0 IN1 IN2 IN3 IN4 IN5 IN6 IN7 OUT0 OUT1 OUT2 OUT3 OUT4
+ OUT5 OUT6 OUT7 VDDA
*.PININFO GNDA:B IN0:B IN1:B IN2:B IN3:B IN4:B IN5:B IN6:B IN7:B OUT0:B OUT1:B
*.PININFO OUT2:B OUT3:B OUT4:B OUT5:B OUT6:B OUT7:B VDDA:B
XI7 IN4 OUT4 VDDA GNDA / IN2
XI6 IN6 OUT6 VDDA GNDA / IN2
XI5 IN7 OUT7 VDDA GNDA / IN2
XI4 IN5 OUT5 VDDA GNDA / IN2
XI3 IN2 OUT2 VDDA GNDA / IN2
XI2 IN3 OUT3 VDDA GNDA / IN2
XI1 IN1 OUT1 VDDA GNDA / IN2
XI0 IN0 OUT0 VDDA GNDA / IN2
.ENDS

************************************************************************
* Library Name: lf11is
* Cell Name:    rnpolym_pcell_7
* View Name:    schematic
************************************************************************

.SUBCKT rnpolym_pcell_7 B MINUS PLUS w=500n l=2u m=1
*.PININFO B:B MINUS:B PLUS:B
RR_0_0 PLUS MINUS $SUB=B $[rnpolym] $W=w $L=l
.ENDS

************************************************************************
* Library Name: lf11is
* Cell Name:    rnpolym_pcell_8
* View Name:    schematic
************************************************************************

.SUBCKT rnpolym_pcell_8 B MINUS PLUS w=500n l=2u m=1
*.PININFO B:B MINUS:B PLUS:B
RR_0_11 PLUS MINUS $SUB=B $[rnpolym] $W=w $L=l
RR_0_10 PLUS MINUS $SUB=B $[rnpolym] $W=w $L=l
RR_0_9 PLUS MINUS $SUB=B $[rnpolym] $W=w $L=l
RR_0_8 PLUS MINUS $SUB=B $[rnpolym] $W=w $L=l
RR_0_7 PLUS MINUS $SUB=B $[rnpolym] $W=w $L=l
RR_0_6 PLUS MINUS $SUB=B $[rnpolym] $W=w $L=l
RR_0_5 PLUS MINUS $SUB=B $[rnpolym] $W=w $L=l
RR_0_4 PLUS MINUS $SUB=B $[rnpolym] $W=w $L=l
RR_0_3 PLUS MINUS $SUB=B $[rnpolym] $W=w $L=l
RR_0_2 PLUS MINUS $SUB=B $[rnpolym] $W=w $L=l
RR_0_1 PLUS MINUS $SUB=B $[rnpolym] $W=w $L=l
RR_0_0 PLUS MINUS $SUB=B $[rnpolym] $W=w $L=l
.ENDS

************************************************************************
* Library Name: REF_GEN
* Cell Name:    trim_res_rnpolyn_2_fL
* View Name:    schematic
************************************************************************

.SUBCKT trim_res_rnpolyn_2_fL GNDA P1 P2
*.PININFO GNDA:B P1:B P2:B
XR0 GNDA net1 P1 / rnpolym_pcell_7 l=35u w=500n m=1
XR11 GNDA P2 net1 / rnpolym_pcell_7 l=35u w=500n m=1
XR1 GNDA P2 P1 / rnpolym_pcell_8 l=35u w=500n m=1
.ENDS

************************************************************************
* Library Name: REF_GEN
* Cell Name:    trim_res_array_rn_2_fL
* View Name:    schematic
************************************************************************

.SUBCKT trim_res_array_rn_2_fL GNDA P1 P2 SEL1 SEL2 SEL3 SEL4
*.PININFO GNDA:B P1:B P2:B SEL1:B SEL2:B SEL3:B SEL4:B
XI19 GNDA P2 net12 / trim_res_rnpolyn_2_fL
XI18 GNDA P2 net12 / trim_res_rnpolyn_2_fL
XI17 GNDA net5 net12 / trim_res_rnpolyn_2_fL
XI16 GNDA net1 net5 / trim_res_rnpolyn_2_fL
XI15 GNDA net7 net1 / trim_res_rnpolyn_2_fL
XI14 GNDA net2 net7 / trim_res_rnpolyn_2_fL
XI9 GNDA net10 net2 / trim_res_rnpolyn_2_fL
XI8 GNDA net4 net10 / trim_res_rnpolyn_2_fL
XI7 GNDA net11 net4 / trim_res_rnpolyn_2_fL
XI6 GNDA SEL4 net11 / trim_res_rnpolyn_2_fL
XI5 GNDA SEL3 SEL4 / trim_res_rnpolyn_2_fL
XI4 GNDA SEL2 SEL3 / trim_res_rnpolyn_2_fL
XI3 GNDA SEL1 SEL2 / trim_res_rnpolyn_2_fL
XI2 GNDA P1 SEL1 / trim_res_rnpolyn_2_fL
.ENDS

************************************************************************
* Library Name: lf11is
* Cell Name:    rnpolym_pcell_9
* View Name:    schematic
************************************************************************

.SUBCKT rnpolym_pcell_9 B MINUS PLUS w=500n l=2u m=1
*.PININFO B:B MINUS:B PLUS:B
RR_0_1 MINUS int_0_1 $SUB=B $[rnpolym] $W=w $L=l
RR_0_0 PLUS int_0_1 $SUB=B $[rnpolym] $W=w $L=l
.ENDS

************************************************************************
* Library Name: lf11is
* Cell Name:    rnpolym_pcell_10
* View Name:    schematic
************************************************************************

.SUBCKT rnpolym_pcell_10 B MINUS PLUS w=500n l=2u m=1
*.PININFO B:B MINUS:B PLUS:B
RR_0_7 MINUS int_0_7 $SUB=B $[rnpolym] $W=w $L=l
RR_0_6 int_0_6 int_0_7 $SUB=B $[rnpolym] $W=w $L=l
RR_0_5 int_0_6 int_0_5 $SUB=B $[rnpolym] $W=w $L=l
RR_0_4 int_0_4 int_0_5 $SUB=B $[rnpolym] $W=w $L=l
RR_0_3 int_0_4 int_0_3 $SUB=B $[rnpolym] $W=w $L=l
RR_0_2 int_0_2 int_0_3 $SUB=B $[rnpolym] $W=w $L=l
RR_0_1 int_0_2 int_0_1 $SUB=B $[rnpolym] $W=w $L=l
RR_0_0 PLUS int_0_1 $SUB=B $[rnpolym] $W=w $L=l
.ENDS

************************************************************************
* Library Name: lf11is
* Cell Name:    rnpolym_pcell_11
* View Name:    schematic
************************************************************************

.SUBCKT rnpolym_pcell_11 B MINUS PLUS w=500n l=2u m=1
*.PININFO B:B MINUS:B PLUS:B
RR_3_0 PLUS MINUS $SUB=B $[rnpolym] $W=w $L=l
RR_2_0 PLUS MINUS $SUB=B $[rnpolym] $W=w $L=l
RR_1_0 PLUS MINUS $SUB=B $[rnpolym] $W=w $L=l
RR_0_0 PLUS MINUS $SUB=B $[rnpolym] $W=w $L=l
.ENDS

************************************************************************
* Library Name: lf11is
* Cell Name:    rnpolym_pcell_12
* View Name:    schematic
************************************************************************

.SUBCKT rnpolym_pcell_12 B MINUS PLUS w=500n l=2u m=1
*.PININFO B:B MINUS:B PLUS:B
RR_0_0 PLUS MINUS $SUB=B $[rnpolym] $W=w $L=l
.ENDS

************************************************************************
* Library Name: lf11is
* Cell Name:    rnpolym_pcell_13
* View Name:    schematic
************************************************************************

.SUBCKT rnpolym_pcell_13 B MINUS PLUS w=500n l=2u m=1
*.PININFO B:B MINUS:B PLUS:B
RR_0_3 MINUS int_0_3 $SUB=B $[rnpolym] $W=w $L=l
RR_0_2 int_0_2 int_0_3 $SUB=B $[rnpolym] $W=w $L=l
RR_0_1 int_0_2 int_0_1 $SUB=B $[rnpolym] $W=w $L=l
RR_0_0 PLUS int_0_1 $SUB=B $[rnpolym] $W=w $L=l
.ENDS

************************************************************************
* Library Name: lf11is
* Cell Name:    rnpolym_pcell_14
* View Name:    schematic
************************************************************************

.SUBCKT rnpolym_pcell_14 B MINUS PLUS w=500n l=2u m=1
*.PININFO B:B MINUS:B PLUS:B
RR_0_21 MINUS int_0_21 $SUB=B $[rnpolym] $W=w $L=l
RR_0_20 int_0_20 int_0_21 $SUB=B $[rnpolym] $W=w $L=l
RR_0_19 int_0_20 int_0_19 $SUB=B $[rnpolym] $W=w $L=l
RR_0_18 int_0_18 int_0_19 $SUB=B $[rnpolym] $W=w $L=l
RR_0_17 int_0_18 int_0_17 $SUB=B $[rnpolym] $W=w $L=l
RR_0_16 int_0_16 int_0_17 $SUB=B $[rnpolym] $W=w $L=l
RR_0_15 int_0_16 int_0_15 $SUB=B $[rnpolym] $W=w $L=l
RR_0_14 int_0_14 int_0_15 $SUB=B $[rnpolym] $W=w $L=l
RR_0_13 int_0_14 int_0_13 $SUB=B $[rnpolym] $W=w $L=l
RR_0_12 int_0_12 int_0_13 $SUB=B $[rnpolym] $W=w $L=l
RR_0_11 int_0_12 int_0_11 $SUB=B $[rnpolym] $W=w $L=l
RR_0_10 int_0_10 int_0_11 $SUB=B $[rnpolym] $W=w $L=l
RR_0_9 int_0_10 int_0_9 $SUB=B $[rnpolym] $W=w $L=l
RR_0_8 int_0_8 int_0_9 $SUB=B $[rnpolym] $W=w $L=l
RR_0_7 int_0_8 int_0_7 $SUB=B $[rnpolym] $W=w $L=l
RR_0_6 int_0_6 int_0_7 $SUB=B $[rnpolym] $W=w $L=l
RR_0_5 int_0_6 int_0_5 $SUB=B $[rnpolym] $W=w $L=l
RR_0_4 int_0_4 int_0_5 $SUB=B $[rnpolym] $W=w $L=l
RR_0_3 int_0_4 int_0_3 $SUB=B $[rnpolym] $W=w $L=l
RR_0_2 int_0_2 int_0_3 $SUB=B $[rnpolym] $W=w $L=l
RR_0_1 int_0_2 int_0_1 $SUB=B $[rnpolym] $W=w $L=l
RR_0_0 PLUS int_0_1 $SUB=B $[rnpolym] $W=w $L=l
.ENDS

************************************************************************
* Library Name: REF_GEN
* Cell Name:    REF_V5_fLC
* View Name:    schematic
************************************************************************

.SUBCKT REF_V5_fLC A0 A1 A2 A3 A4 A5 A6 A7 BG_REF BIAS CJ_G1<0> CJ_G1<1>
+ CJ_G1<2> CJ_G1<3> CJ_G1<4> CJ_G1<5> CJ_G2<0> CJ_G2<1> CJ_G2<2> CJ_G2<3>
+ CJ_G2<4> CJ_G2<5> CJ_G3<0> CJ_G3<1> CJ_G3<2> CJ_G3<3> CJ_G3<4> CJ_G3<5>
+ CJ_G4<0> CJ_G4<1> CJ_G4<2> CJ_G4<3> CJ_G4<4> CJ_G4<5> CL1X_1 CL4X_1 CL4X_2
+ EN GNDA Ib128nAT LDO_REF LDO_SEL<0> LDO_SEL<1> LDO_SEL<2> LDO_SEL<3>
+ LVDS_REF LVDS_SEL<0> LVDS_SEL<1> LVDS_SEL<2> LVDS_SEL<3> LVDS_SEL<4>
+ LVDS_SEL<5> LVDS_SEL<6> LVDS_SEL<7> V1000 V550 VDDA
*.PININFO A0:B A1:B A2:B A3:B A4:B A5:B A6:B A7:B BG_REF:B BIAS:B CJ_G1<0>:B
*.PININFO CJ_G1<1>:B CJ_G1<2>:B CJ_G1<3>:B CJ_G1<4>:B CJ_G1<5>:B CJ_G2<0>:B
*.PININFO CJ_G2<1>:B CJ_G2<2>:B CJ_G2<3>:B CJ_G2<4>:B CJ_G2<5>:B CJ_G3<0>:B
*.PININFO CJ_G3<1>:B CJ_G3<2>:B CJ_G3<3>:B CJ_G3<4>:B CJ_G3<5>:B CJ_G4<0>:B
*.PININFO CJ_G4<1>:B CJ_G4<2>:B CJ_G4<3>:B CJ_G4<4>:B CJ_G4<5>:B CL1X_1:B
*.PININFO CL4X_1:B CL4X_2:B EN:B GNDA:B Ib128nAT:B LDO_REF:B LDO_SEL<0>:B
*.PININFO LDO_SEL<1>:B LDO_SEL<2>:B LDO_SEL<3>:B LVDS_REF:B LVDS_SEL<0>:B
*.PININFO LVDS_SEL<1>:B LVDS_SEL<2>:B LVDS_SEL<3>:B LVDS_SEL<4>:B
*.PININFO LVDS_SEL<5>:B LVDS_SEL<6>:B LVDS_SEL<7>:B V550:B V1000:B VDDA:B
MM87 net41 PD GNDA GNDA nmos1v2hvt W=1u L=500n m=1 nf=1
MM84 net51 PD GNDA GNDA nmos1v2hvt W=1u L=500n m=1 nf=1
MM83 BIAS PDN net51 GNDA nmos1v2hvt W=1u L=500n m=1 nf=1
MM81 PDN PD GNDA GNDA nmos1v2hvt W=1u L=500n m=1 nf=1
MM88 PD EN GNDA GNDA nmos1v2hvt W=1u L=500n m=1 nf=1
MM93 GNDA GNDA GNDA GNDA nmos1v2hvt W=18.75u L=2u m=4 nf=1
MM16 net49 net44 net50 GNDA nmos1v2hvt W=16u L=4u m=1 nf=2
MM15 net50 net41 GNDA GNDA nmos1v2hvt W=8u L=4u m=2 nf=1
MM14 net16 net16 net44 GNDA nmos1v2hvt W=16u L=4u m=1 nf=2
MM13 net44 net44 net41 GNDA nmos1v2hvt W=16u L=4u m=1 nf=2
MM12 net41 net41 GNDA GNDA nmos1v2hvt W=8u L=4u m=2 nf=1
MM7 net11 net1 net26 GNDA nmos1v2hvt W=18.75u L=2u m=32 nf=1
MM6 net53 BG_REF net26 GNDA nmos1v2hvt W=18.75u L=2u m=32 nf=1
MM8 net26 net51 GNDA GNDA nmos1v2hvt W=8u L=4u m=2 nf=1
MM11 net51 net51 GNDA GNDA nmos1v2hvt W=8u L=4u m=2 nf=1
MM86 net53 PDN VDDA VDDA pmos1v2hvt W=2u L=500n m=1 nf=1
MM85 net11 PDN VDDA VDDA pmos1v2hvt W=2u L=500n m=1 nf=1
MM82 PDN PD VDDA VDDA pmos1v2hvt W=2u L=500n m=1 nf=1
MM94 VDDA VDDA VDDA VDDA pmos1v2hvt W=10u L=2u m=2 nf=1
MM92 VDDA VDDA VDDA VDDA pmos1v2hvt W=25u L=2u m=4 nf=1
MM72 net47 net53 VDDA VDDA pmos1v2hvt W=10u L=2u m=1 nf=1
MM71 CJ_G3<1> net49 net48 VDDA pmos1v2hvt W=10u L=2u m=1 nf=1
MM70 net48 net53 VDDA VDDA pmos1v2hvt W=10u L=2u m=1 nf=1
MM69 CJ_G3<0> net49 net47 VDDA pmos1v2hvt W=10u L=2u m=1 nf=1
MM68 net38 net53 VDDA VDDA pmos1v2hvt W=10u L=2u m=1 nf=1
MM67 CJ_G4<1> net49 net46 VDDA pmos1v2hvt W=10u L=2u m=1 nf=1
MM66 net46 net53 VDDA VDDA pmos1v2hvt W=10u L=2u m=1 nf=1
MM65 CJ_G4<0> net49 net38 VDDA pmos1v2hvt W=10u L=2u m=1 nf=1
MM64 CJ_G4<5> net49 net37 VDDA pmos1v2hvt W=40u L=2u m=1 nf=4
MM63 net37 net53 VDDA VDDA pmos1v2hvt W=10u L=2u m=4 nf=1
MM62 net36 net53 VDDA VDDA pmos1v2hvt W=10u L=2u m=1 nf=1
MM61 CJ_G4<4> net49 net36 VDDA pmos1v2hvt W=10u L=2u m=1 nf=1
MM60 net35 net53 VDDA VDDA pmos1v2hvt W=10u L=2u m=1 nf=1
MM59 CJ_G4<3> net49 net35 VDDA pmos1v2hvt W=10u L=2u m=1 nf=1
MM58 CJ_G4<2> net49 net45 VDDA pmos1v2hvt W=10u L=2u m=1 nf=1
MM57 net45 net53 VDDA VDDA pmos1v2hvt W=10u L=2u m=1 nf=1
MM56 CJ_G3<5> net49 net43 VDDA pmos1v2hvt W=40u L=2u m=1 nf=4
MM55 net43 net53 VDDA VDDA pmos1v2hvt W=10u L=2u m=4 nf=1
MM54 net42 net53 VDDA VDDA pmos1v2hvt W=10u L=2u m=1 nf=1
MM53 CJ_G3<4> net49 net42 VDDA pmos1v2hvt W=10u L=2u m=1 nf=1
MM52 net40 net53 VDDA VDDA pmos1v2hvt W=10u L=2u m=1 nf=1
MM51 CJ_G3<3> net49 net40 VDDA pmos1v2hvt W=10u L=2u m=1 nf=1
MM50 CJ_G3<2> net49 net39 VDDA pmos1v2hvt W=10u L=2u m=1 nf=1
MM49 net39 net53 VDDA VDDA pmos1v2hvt W=10u L=2u m=1 nf=1
MM48 net32 net53 VDDA VDDA pmos1v2hvt W=10u L=2u m=1 nf=1
MM47 CJ_G2<1> net49 net33 VDDA pmos1v2hvt W=10u L=2u m=1 nf=1
MM46 net33 net53 VDDA VDDA pmos1v2hvt W=10u L=2u m=1 nf=1
MM45 CJ_G2<0> net49 net32 VDDA pmos1v2hvt W=10u L=2u m=1 nf=1
MM44 CJ_G2<5> net49 net30 VDDA pmos1v2hvt W=40u L=2u m=1 nf=4
MM43 net30 net53 VDDA VDDA pmos1v2hvt W=10u L=2u m=4 nf=1
MM42 net29 net53 VDDA VDDA pmos1v2hvt W=10u L=2u m=1 nf=1
MM41 CJ_G2<4> net49 net29 VDDA pmos1v2hvt W=10u L=2u m=1 nf=1
MM40 net27 net53 VDDA VDDA pmos1v2hvt W=10u L=2u m=1 nf=1
MM39 CJ_G2<3> net49 net27 VDDA pmos1v2hvt W=10u L=2u m=1 nf=1
MM38 CJ_G2<2> net49 net31 VDDA pmos1v2hvt W=10u L=2u m=1 nf=1
MM37 net31 net53 VDDA VDDA pmos1v2hvt W=10u L=2u m=1 nf=1
MM36 CJ_G1<5> net49 net25 VDDA pmos1v2hvt W=40u L=2u m=1 nf=4
MM35 net25 net53 VDDA VDDA pmos1v2hvt W=10u L=2u m=4 nf=1
MM34 net24 net53 VDDA VDDA pmos1v2hvt W=10u L=2u m=1 nf=1
MM33 CJ_G1<4> net49 net24 VDDA pmos1v2hvt W=10u L=2u m=1 nf=1
MM32 net23 net53 VDDA VDDA pmos1v2hvt W=10u L=2u m=1 nf=1
MM22 CL4X_1 net49 net20 VDDA pmos1v2hvt W=40u L=2u m=1 nf=4
MM19 CL1X_1 net49 net17 VDDA pmos1v2hvt W=10u L=2u m=1 nf=1
MM18 net49 net49 net65 VDDA pmos1v2hvt W=10u L=1u m=1 nf=1
MM17 net65 net65 VDDA VDDA pmos1v2hvt W=10u L=500n m=1 nf=1
MM5 net16 net53 VDDA VDDA pmos1v2hvt W=10u L=2u m=1 nf=1
MM89 PD EN VDDA VDDA pmos1v2hvt W=2u L=500n m=1 nf=1
MM4 net20 net53 VDDA VDDA pmos1v2hvt W=10u L=2u m=4 nf=1
MM91 net64 net53 VDDA VDDA pmos1v2hvt W=10u L=2u m=4 nf=1
MM90 Ib128nAT net49 net64 VDDA pmos1v2hvt W=40u L=2u m=1 nf=4
MM1 net17 net53 VDDA VDDA pmos1v2hvt W=10u L=2u m=1 nf=1
MM25 CJ_G1<0> net49 net28 VDDA pmos1v2hvt W=10u L=2u m=1 nf=1
MM26 net28 net53 VDDA VDDA pmos1v2hvt W=10u L=2u m=1 nf=1
MM31 CJ_G1<3> net49 net23 VDDA pmos1v2hvt W=10u L=2u m=1 nf=1
MM30 CJ_G1<2> net49 net22 VDDA pmos1v2hvt W=10u L=2u m=1 nf=1
MM29 net22 net53 VDDA VDDA pmos1v2hvt W=10u L=2u m=1 nf=1
MM27 CJ_G1<1> net49 net21 VDDA pmos1v2hvt W=10u L=2u m=1 nf=1
MM28 net21 net53 VDDA VDDA pmos1v2hvt W=10u L=2u m=1 nf=1
MM95 V1000 net53 V1000 V1000 pmos1v2hvt W=25u L=10u m=16 nf=1
MM24 net10 net53 VDDA VDDA pmos1v2hvt W=10u L=2u m=4 nf=1
MM23 CL4X_2 net49 net10 VDDA pmos1v2hvt W=40u L=2u m=1 nf=4
MM0 V1000 net53 VDDA VDDA pmos1v2hvt W=10u L=2u m=40 nf=1
MM10 net53 net11 VDDA VDDA pmos1v2hvt W=25u L=10u m=8 nf=1
MM9 net11 net11 VDDA VDDA pmos1v2hvt W=25u L=10u m=8 nf=1
XI8 net56 net57 net58 net59 VDDA VDDA VDDA VDDA LDO_REF V700 V800 V900 V1000
+ VDDA VDDA VDDA VDDA VDDA / mux8_1p_fL
XI7 net55 net54 net52 net34 net19 net18 net8 net3 LVDS_REF V825 V850 V875 V900
+ V925 V950 V975 V650 VDDA / mux8_1p_fL
XI6 A0 A1 A2 A3 A4 A5 A6 A7 net1 GNDA net9 net2 net7 VX net5 net14 net13 net12
+ / mux8_1_fL
XI10 GNDA LDO_SEL<0> LDO_SEL<1> LDO_SEL<2> LDO_SEL<3> GNDA GNDA GNDA GNDA
+ net56 net57 net58 net59 net60 net61 net62 net63 VDDA / inv8_fL
XI9 GNDA LVDS_SEL<0> LVDS_SEL<1> LVDS_SEL<2> LVDS_SEL<3> LVDS_SEL<4>
+ LVDS_SEL<5> LVDS_SEL<6> LVDS_SEL<7> net55 net54 net52 net34 net19 net18 net8
+ net3 VDDA / inv8_fL
XI3 GNDA VX net4 net5 net14 net13 net12 / trim_res_array_rn_2_fL
XI4 GNDA VX net6 net7 net2 net9 net15 / trim_res_array_rn_2_fL
XR13 GNDA V650 V700 / rnpolym_pcell_9 l=35u w=500n m=1
XR14 GNDA GNDA GNDA / rnpolym_pcell_10 l=35u w=500n m=1
XR15 GNDA GNDA GNDA / rnpolym_pcell_11 l=35u w=500n m=4
XR1 GNDA V975 V1000 / rnpolym_pcell_12 l=35u w=500n m=1
XR2 GNDA V950 V975 / rnpolym_pcell_12 l=35u w=500n m=1
XR3 GNDA V925 V950 / rnpolym_pcell_12 l=35u w=500n m=1
XR4 GNDA V900 V925 / rnpolym_pcell_12 l=35u w=500n m=1
XR5 GNDA V875 V900 / rnpolym_pcell_12 l=35u w=500n m=1
XR8 GNDA V800 V825 / rnpolym_pcell_12 l=35u w=500n m=1
XR7 GNDA V825 V850 / rnpolym_pcell_12 l=35u w=500n m=1
XR11 GNDA V550 net6 / rnpolym_pcell_7 l=35u w=500n m=1
XR6 GNDA V850 V875 / rnpolym_pcell_12 l=35u w=500n m=1
XR9 GNDA V700 V800 / rnpolym_pcell_13 l=35u w=500n m=1
XR10 GNDA net4 V650 / rnpolym_pcell_7 l=35u w=500n m=1
XR12 GNDA GNDA V550 / rnpolym_pcell_14 l=35u w=500n m=1
.ENDS

************************************************************************
* Library Name: lf11is
* Cell Name:    rnpolym_pcell_15
* View Name:    schematic
************************************************************************

.SUBCKT rnpolym_pcell_15 B MINUS PLUS w=500n l=2u m=1
*.PININFO B:B MINUS:B PLUS:B
RR_0_74 int_0_74 MINUS $SUB=B $[rnpolym] $W=w $L=l
RR_0_73 int_0_74 int_0_73 $SUB=B $[rnpolym] $W=w $L=l
RR_0_72 int_0_72 int_0_73 $SUB=B $[rnpolym] $W=w $L=l
RR_0_71 int_0_72 int_0_71 $SUB=B $[rnpolym] $W=w $L=l
RR_0_70 int_0_70 int_0_71 $SUB=B $[rnpolym] $W=w $L=l
RR_0_69 int_0_70 int_0_69 $SUB=B $[rnpolym] $W=w $L=l
RR_0_68 int_0_68 int_0_69 $SUB=B $[rnpolym] $W=w $L=l
RR_0_67 int_0_68 int_0_67 $SUB=B $[rnpolym] $W=w $L=l
RR_0_66 int_0_66 int_0_67 $SUB=B $[rnpolym] $W=w $L=l
RR_0_65 int_0_66 int_0_65 $SUB=B $[rnpolym] $W=w $L=l
RR_0_64 int_0_64 int_0_65 $SUB=B $[rnpolym] $W=w $L=l
RR_0_63 int_0_64 int_0_63 $SUB=B $[rnpolym] $W=w $L=l
RR_0_62 int_0_62 int_0_63 $SUB=B $[rnpolym] $W=w $L=l
RR_0_61 int_0_62 int_0_61 $SUB=B $[rnpolym] $W=w $L=l
RR_0_60 int_0_60 int_0_61 $SUB=B $[rnpolym] $W=w $L=l
RR_0_59 int_0_60 int_0_59 $SUB=B $[rnpolym] $W=w $L=l
RR_0_58 int_0_58 int_0_59 $SUB=B $[rnpolym] $W=w $L=l
RR_0_57 int_0_58 int_0_57 $SUB=B $[rnpolym] $W=w $L=l
RR_0_56 int_0_56 int_0_57 $SUB=B $[rnpolym] $W=w $L=l
RR_0_55 int_0_56 int_0_55 $SUB=B $[rnpolym] $W=w $L=l
RR_0_54 int_0_54 int_0_55 $SUB=B $[rnpolym] $W=w $L=l
RR_0_53 int_0_54 int_0_53 $SUB=B $[rnpolym] $W=w $L=l
RR_0_52 int_0_52 int_0_53 $SUB=B $[rnpolym] $W=w $L=l
RR_0_51 int_0_52 int_0_51 $SUB=B $[rnpolym] $W=w $L=l
RR_0_50 int_0_50 int_0_51 $SUB=B $[rnpolym] $W=w $L=l
RR_0_49 int_0_50 int_0_49 $SUB=B $[rnpolym] $W=w $L=l
RR_0_48 int_0_48 int_0_49 $SUB=B $[rnpolym] $W=w $L=l
RR_0_47 int_0_48 int_0_47 $SUB=B $[rnpolym] $W=w $L=l
RR_0_46 int_0_46 int_0_47 $SUB=B $[rnpolym] $W=w $L=l
RR_0_45 int_0_46 int_0_45 $SUB=B $[rnpolym] $W=w $L=l
RR_0_44 int_0_44 int_0_45 $SUB=B $[rnpolym] $W=w $L=l
RR_0_43 int_0_44 int_0_43 $SUB=B $[rnpolym] $W=w $L=l
RR_0_42 int_0_42 int_0_43 $SUB=B $[rnpolym] $W=w $L=l
RR_0_41 int_0_42 int_0_41 $SUB=B $[rnpolym] $W=w $L=l
RR_0_40 int_0_40 int_0_41 $SUB=B $[rnpolym] $W=w $L=l
RR_0_39 int_0_40 int_0_39 $SUB=B $[rnpolym] $W=w $L=l
RR_0_38 int_0_38 int_0_39 $SUB=B $[rnpolym] $W=w $L=l
RR_0_37 int_0_38 int_0_37 $SUB=B $[rnpolym] $W=w $L=l
RR_0_36 int_0_36 int_0_37 $SUB=B $[rnpolym] $W=w $L=l
RR_0_35 int_0_36 int_0_35 $SUB=B $[rnpolym] $W=w $L=l
RR_0_34 int_0_34 int_0_35 $SUB=B $[rnpolym] $W=w $L=l
RR_0_33 int_0_34 int_0_33 $SUB=B $[rnpolym] $W=w $L=l
RR_0_32 int_0_32 int_0_33 $SUB=B $[rnpolym] $W=w $L=l
RR_0_31 int_0_32 int_0_31 $SUB=B $[rnpolym] $W=w $L=l
RR_0_30 int_0_30 int_0_31 $SUB=B $[rnpolym] $W=w $L=l
RR_0_29 int_0_30 int_0_29 $SUB=B $[rnpolym] $W=w $L=l
RR_0_28 int_0_28 int_0_29 $SUB=B $[rnpolym] $W=w $L=l
RR_0_27 int_0_28 int_0_27 $SUB=B $[rnpolym] $W=w $L=l
RR_0_26 int_0_26 int_0_27 $SUB=B $[rnpolym] $W=w $L=l
RR_0_25 int_0_26 int_0_25 $SUB=B $[rnpolym] $W=w $L=l
RR_0_24 int_0_24 int_0_25 $SUB=B $[rnpolym] $W=w $L=l
RR_0_23 int_0_24 int_0_23 $SUB=B $[rnpolym] $W=w $L=l
RR_0_22 int_0_22 int_0_23 $SUB=B $[rnpolym] $W=w $L=l
RR_0_21 int_0_22 int_0_21 $SUB=B $[rnpolym] $W=w $L=l
RR_0_20 int_0_20 int_0_21 $SUB=B $[rnpolym] $W=w $L=l
RR_0_19 int_0_20 int_0_19 $SUB=B $[rnpolym] $W=w $L=l
RR_0_18 int_0_18 int_0_19 $SUB=B $[rnpolym] $W=w $L=l
RR_0_17 int_0_18 int_0_17 $SUB=B $[rnpolym] $W=w $L=l
RR_0_16 int_0_16 int_0_17 $SUB=B $[rnpolym] $W=w $L=l
RR_0_15 int_0_16 int_0_15 $SUB=B $[rnpolym] $W=w $L=l
RR_0_14 int_0_14 int_0_15 $SUB=B $[rnpolym] $W=w $L=l
RR_0_13 int_0_14 int_0_13 $SUB=B $[rnpolym] $W=w $L=l
RR_0_12 int_0_12 int_0_13 $SUB=B $[rnpolym] $W=w $L=l
RR_0_11 int_0_12 int_0_11 $SUB=B $[rnpolym] $W=w $L=l
RR_0_10 int_0_10 int_0_11 $SUB=B $[rnpolym] $W=w $L=l
RR_0_9 int_0_10 int_0_9 $SUB=B $[rnpolym] $W=w $L=l
RR_0_8 int_0_8 int_0_9 $SUB=B $[rnpolym] $W=w $L=l
RR_0_7 int_0_8 int_0_7 $SUB=B $[rnpolym] $W=w $L=l
RR_0_6 int_0_6 int_0_7 $SUB=B $[rnpolym] $W=w $L=l
RR_0_5 int_0_6 int_0_5 $SUB=B $[rnpolym] $W=w $L=l
RR_0_4 int_0_4 int_0_5 $SUB=B $[rnpolym] $W=w $L=l
RR_0_3 int_0_4 int_0_3 $SUB=B $[rnpolym] $W=w $L=l
RR_0_2 int_0_2 int_0_3 $SUB=B $[rnpolym] $W=w $L=l
RR_0_1 int_0_2 int_0_1 $SUB=B $[rnpolym] $W=w $L=l
RR_0_0 PLUS int_0_1 $SUB=B $[rnpolym] $W=w $L=l
.ENDS

************************************************************************
* Library Name: REF_GEN
* Cell Name:    CONSTANT_GM_2_fL
* View Name:    schematic
************************************************************************

.SUBCKT CONSTANT_GM_2_fL EN GNDA IOUT1 IOUT2 VDDA
*.PININFO EN:B GNDA:B IOUT1:B IOUT2:B VDDA:B
MM14 GNDA GNDA GNDA GNDA nmos1v2hvt W=10u L=2u m=2 nf=1
MM84 net3 PD GNDA GNDA nmos1v2hvt W=1u L=1u m=1 nf=1
MM81 PDN PD GNDA GNDA nmos1v2hvt W=1u L=500n m=1 nf=1
MM3 net1 net10 net7 GNDA nmos1v2hvt W=10u L=10u m=1 nf=1
MM2 net10 net10 net3 GNDA nmos1v2hvt W=10u L=10u m=1 nf=1
MM1 net7 net3 net2 GNDA nmos1v2hvt W=10u L=2u m=4 nf=1
MM88 PD EN GNDA GNDA nmos1v2hvt W=1u L=500n m=1 nf=1
MM0 net3 net3 GNDA GNDA nmos1v2hvt W=10u L=2u m=1 nf=1
MM15 VDDA VDDA VDDA VDDA pmos1v2hvt W=10u L=5u m=4 nf=1
MM86 net5 PDN VDDA VDDA pmos1v2hvt W=2u L=1u m=1 nf=1
MM82 PDN PD VDDA VDDA pmos1v2hvt W=2u L=500n m=1 nf=1
MM89 PD EN VDDA VDDA pmos1v2hvt W=2u L=500n m=1 nf=1
MM13 net8 net5 VDDA VDDA pmos1v2hvt W=10u L=5u m=4 nf=1
MM12 IOUT2 net1 net8 VDDA pmos1v2hvt W=40u L=5u m=1 nf=4
MM11 net10 net10 net4 VDDA pmos1v2hvt W=1u L=500n m=1 nf=1
MM10 net4 net4 net1 VDDA pmos1v2hvt W=1u L=500n m=1 nf=1
MM9 IOUT1 net1 net6 VDDA pmos1v2hvt W=40u L=5u m=1 nf=4
MM8 net6 net5 VDDA VDDA pmos1v2hvt W=10u L=5u m=4 nf=1
MM7 net1 net1 net5 VDDA pmos1v2hvt W=10u L=5u m=1 nf=1
MM6 net5 net5 VDDA VDDA pmos1v2hvt W=10u L=5u m=1 nf=1
MM5 net10 net1 net9 VDDA pmos1v2hvt W=10u L=5u m=1 nf=1
MM4 net9 net5 VDDA VDDA pmos1v2hvt W=10u L=5u m=1 nf=1
XC1 IOUT2 GNDA GNDA ncap1v2hvt M=4 W=20u L=10u $W=20u $L=10u
XC0 IOUT1 GNDA GNDA ncap1v2hvt M=4 W=20u L=10u $W=20u $L=10u
XR1 GNDA GNDA net11 / rnpolym_pcell_15 l=10u w=500n m=1
XR0 GNDA net11 net2 / rnpolym_pcell_15 l=10u w=500n m=1
.ENDS

************************************************************************
* Library Name: REF_GEN
* Cell Name:    mux2_1_fL
* View Name:    schematic
************************************************************************

.SUBCKT mux2_1_fL COM GNDA IN0 IN1 S VDDA
*.PININFO COM:B GNDA:B IN0:B IN1:B S:B VDDA:B
MM49 SN S GNDA GNDA nmos1v2hvt W=1u L=1u m=1 nf=1
MM2 IN1 S COM GNDA nmos1v2hvt W=2u L=1u m=1 nf=1
MM1 IN0 SN COM GNDA nmos1v2hvt W=2u L=1u m=1 nf=1
MM0 COM S IN0 VDDA pmos1v2hvt W=4u L=1u m=1 nf=1
MM50 SN S VDDA VDDA pmos1v2hvt W=2u L=1u m=1 nf=1
MM3 COM SN IN1 VDDA pmos1v2hvt W=4u L=1u m=1 nf=1
.ENDS

************************************************************************
* Library Name: REF_GEN
* Cell Name:    LS3
* View Name:    schematic
************************************************************************

.SUBCKT LS3 GNDA GNDD IN0 IN1 IN2 OUT0 OUT1 OUT2 VDDA VDDD
*.PININFO GNDA:B GNDD:B IN0:B IN1:B IN2:B OUT0:B OUT1:B OUT2:B VDDA:B VDDD:B
XI2 IN2 OUT2 VDDA VDDD GNDA GNDD net18 / LS
XI1 IN1 OUT1 VDDA VDDD GNDA GNDD net12 / LS
XI0 IN0 OUT0 VDDA VDDD GNDA GNDD net6 / LS
.ENDS

************************************************************************
* Library Name: REF_GEN
* Cell Name:    LS2
* View Name:    schematic
************************************************************************

.SUBCKT LS2 GNDA GNDD IN0 IN1 OUT0 OUT1 VDDA VDDD
*.PININFO GNDA:B GNDD:B IN0:B IN1:B OUT0:B OUT1:B VDDA:B VDDD:B
XI1 IN1 OUT1 VDDA VDDD GNDA GNDD net12 / LS
XI0 IN0 OUT0 VDDA VDDD GNDA GNDD net6 / LS
.ENDS

************************************************************************
* Library Name: REF_GEN
* Cell Name:    REF_GEN_fL_2
* View Name:    schematic
************************************************************************

.SUBCKT REF_GEN_fL_2 N0 BG_SL_TRIM<2> BG_SL_TRIM<1> BG_SL_TRIM<0> BG_TRIM<2>
+ BG_TRIM<1> BG_TRIM<0> CJ_G1<0> CJ_G1<1> CJ_G1<2> CJ_G1<3> CJ_G1<4> CJ_G1<5>
+ CJ_G2<0> CJ_G2<1> CJ_G2<2> CJ_G2<3> CJ_G2<4> CJ_G2<5> CJ_G3<0> CJ_G3<1>
+ CJ_G3<2> CJ_G3<3> CJ_G3<4> CJ_G3<5> CJ_G4<0> CJ_G4<1> CJ_G4<2> CJ_G4<3>
+ CJ_G4<4> CJ_G4<5> CL1X_1 CL4X_1 CL4X_2 EN GNDA GNDD LDO_REF LDO_SEL<1>
+ LDO_SEL<0> LVDS_REF LVDS_SEL<2> LVDS_SEL<1> LVDS_SEL<0> PRN REF_TRIM<2>
+ REF_TRIM<1> REF_TRIM<0> Test128nASrc TestVbg V1000 V550 VBREF_SEL VDDA VDDD
+ VbgT
*.PININFO N0:B BG_SL_TRIM<2>:B BG_SL_TRIM<1>:B BG_SL_TRIM<0>:B BG_TRIM<2>:B
*.PININFO BG_TRIM<1>:B BG_TRIM<0>:B CJ_G1<0>:B CJ_G1<1>:B CJ_G1<2>:B
*.PININFO CJ_G1<3>:B CJ_G1<4>:B CJ_G1<5>:B CJ_G2<0>:B CJ_G2<1>:B CJ_G2<2>:B
*.PININFO CJ_G2<3>:B CJ_G2<4>:B CJ_G2<5>:B CJ_G3<0>:B CJ_G3<1>:B CJ_G3<2>:B
*.PININFO CJ_G3<3>:B CJ_G3<4>:B CJ_G3<5>:B CJ_G4<0>:B CJ_G4<1>:B CJ_G4<2>:B
*.PININFO CJ_G4<3>:B CJ_G4<4>:B CJ_G4<5>:B CL1X_1:B CL4X_1:B CL4X_2:B EN:B
*.PININFO GNDA:B GNDD:B LDO_REF:B LDO_SEL<1>:B LDO_SEL<0>:B LVDS_REF:B
*.PININFO LVDS_SEL<2>:B LVDS_SEL<1>:B LVDS_SEL<0>:B PRN:B REF_TRIM<2>:B
*.PININFO REF_TRIM<1>:B REF_TRIM<0>:B Test128nASrc:B TestVbg:B V550:B V1000:B
*.PININFO VBREF_SEL:B VDDA:B VDDD:B VbgT:B
XI28 GNDA GNDD EN EN_LS VDDA VDDD / LS1
XI27 GNDA GNDD VBREF_SEL net59 VDDA VDDD / LS1
XI10 net49 net50 net51 net18 net17 net16 net15 net14 net13 net12 net3 VDDA
+ VDDA GNDA / 3to8DeMuxSel
XI11 net45 net46 net48 net4 net7 net11 net5 net9 net2 net8 net6 VDDA VDDA GNDA
+ / 3to8DeMuxSel
XI12 net57 net56 net58 net24 net25 net19 net21 net23 net22 net20 net26 VDDA
+ VDDA GNDA / 3to8DeMuxSel
XI13 net53 net54 net55 net30 net29 net28 net27 net31 net32 net33 net34 VDDA
+ VDDA GNDA / 3to8DeMuxSel
XI14 net35 net52 GNDA net40 net39 net38 net37 net41 net42 net43 net44 VDDA
+ VDDA GNDA / 3to8DeMuxSel
XI0 BIAS EN_LS GNDA PRN net18 net17 net16 net15 net14 net13 net12 net3 net4
+ net7 net11 net5 net9 net2 net8 net6 VDDA VREF / BG_TRIM_4_fL
XI15 VREF VbgT net47 VDDA GNDA / Tsw
XI18 IT128nA N0 net36 VDDA GNDA / Tsw
XI7 net24 net25 net19 net21 net23 net22 net20 net26 net1 net10 CJ_G1<0>
+ CJ_G1<1> CJ_G1<2> CJ_G1<3> CJ_G1<4> CJ_G1<5> CJ_G2<0> CJ_G2<1> CJ_G2<2>
+ CJ_G2<3> CJ_G2<4> CJ_G2<5> CJ_G3<0> CJ_G3<1> CJ_G3<2> CJ_G3<3> CJ_G3<4>
+ CJ_G3<5> CJ_G4<0> CJ_G4<1> CJ_G4<2> CJ_G4<3> CJ_G4<4> CJ_G4<5> CL1X_1 CL4X_1
+ CL4X_2 EN_LS GNDA IT128nA LDO_REF net40 net39 net38 net37 LVDS_REF net30
+ net29 net28 net27 net31 net32 net33 net34 V1000 V550 VDDA / REF_V5_fLC
XI3 EN_LS GNDA BIAS net10 VDDA / CONSTANT_GM_2_fL
XI9 net1 GNDA VREF VbgT net59 VDDA / mux2_1_fL
XI23 GNDA GNDD LVDS_SEL<0> LVDS_SEL<1> LVDS_SEL<2> net53 net54 net55 VDDA VDDD
+ / LS3
XI19 GNDA GNDD BG_SL_TRIM<0> BG_SL_TRIM<1> BG_SL_TRIM<2> net45 net46 net48
+ VDDA VDDD / LS3
XI20 GNDA GNDD BG_TRIM<0> BG_TRIM<1> BG_TRIM<2> net49 net50 net51 VDDA VDDD /
+ LS3
XI24 GNDA GNDD REF_TRIM<0> REF_TRIM<1> REF_TRIM<2> net57 net56 net58 VDDA VDDD
+ / LS3
XI22 GNDA GNDD LDO_SEL<0> LDO_SEL<1> net35 net52 VDDA VDDD / LS2
XI21 GNDA GNDD TestVbg Test128nASrc net47 net36 VDDA VDDD / LS2
DD0 GNDA BG_SL_TRIM<1> dnppw1v2 M=1 AREA=152.1f PJ=1.56u
.ENDS
