* +++++++++++++++++++++++++++++++++++++++++++++++++++++++++ *
* CDL Netlist:                                              *
*                                                           *
* Cell Name  : REF_V5_fLC                                   *
* Netlisted  : Mon Jul  6 14:15:59 2026                     *
* PVS Version: 24.11-s045 Mon Jan 27 22:18:54 PST 2025      *
* +++++++++++++++++++++++++++++++++++++++++++++++++++++++++ *
*.LDD
*.DEVTMPLT 0 MN(nmos1v2hvt) NMOS1V2HVT NDIFF(D) NGATE(G) NDIFF(S) PW1V2(B)
*.DEVTMPLT 1 MP(pmos1v2hvt) PMOS1V2HVT PDIFF(D) PGATE(G) PDIFF(S) NW1V2(B)
*.DEVTMPLT 2 R(rnpolym) RNPOLYMNW1V2 POLYG3(POS) POLYG3(NEG) NW1V2(SUB)

* +++++++++++++++++++++++++++++++++++++++++++++++++++++++++ *
* Sub cell: pmos1v2hvt_4_CDNS_783347355090                  *
* +++++++++++++++++++++++++++++++++++++++++++++++++++++++++ *
.subckt pmos1v2hvt_4_CDNS_783347355090 1 2 3 4
** N=5 EP=4 FDC=1
M0 3 1 2 4 pmos1v2hvt L=2e-06 W=1e-05 AD=3e-12 AS=3e-12 PD=1.06e-05 PS=1.06e-05 m=1 $X=0 $Y=0 $dt=1
.ends pmos1v2hvt_4_CDNS_783347355090

* +++++++++++++++++++++++++++++++++++++++++++++++++++++++++ *
* Sub cell: pmos1v2hvt_4_CDNS_783347355095                  *
* +++++++++++++++++++++++++++++++++++++++++++++++++++++++++ *
.subckt pmos1v2hvt_4_CDNS_783347355095 1 2
** N=3 EP=2 FDC=1
M0 1 1 2 2 pmos1v2hvt L=5e-07 W=1e-05 AD=3e-12 AS=3e-12 PD=1.06e-05 PS=1.06e-05 m=1 $X=0 $Y=0 $dt=1
.ends pmos1v2hvt_4_CDNS_783347355095

* +++++++++++++++++++++++++++++++++++++++++++++++++++++++++ *
* Sub cell: nmos1v2hvt_4_CDNS_783347355098                  *
* +++++++++++++++++++++++++++++++++++++++++++++++++++++++++ *
.subckt nmos1v2hvt_4_CDNS_783347355098 1 2 3 4
** N=4 EP=4 FDC=1
M0 4 1 2 3 nmos1v2hvt L=5e-07 W=1e-06 AD=3e-13 AS=3e-13 PD=1.6e-06 PS=1.6e-06 m=1 $X=0 $Y=0 $dt=0
.ends nmos1v2hvt_4_CDNS_783347355098

* +++++++++++++++++++++++++++++++++++++++++++++++++++++++++ *
* Sub cell: pmos1v2hvt_4_CDNS_7833473550911                 *
* +++++++++++++++++++++++++++++++++++++++++++++++++++++++++ *
.subckt pmos1v2hvt_4_CDNS_7833473550911 1 2 3
** N=4 EP=3 FDC=1
M0 3 1 2 2 pmos1v2hvt L=5e-07 W=2e-06 AD=6e-13 AS=6e-13 PD=2.6e-06 PS=2.6e-06 m=1 $X=0 $Y=0 $dt=1
.ends pmos1v2hvt_4_CDNS_7833473550911

* +++++++++++++++++++++++++++++++++++++++++++++++++++++++++ *
* Sub cell: rnpolym_CDNS_7833473550913                      *
* +++++++++++++++++++++++++++++++++++++++++++++++++++++++++ *
.subckt rnpolym_CDNS_7833473550913 1 2 3
** N=4 EP=3 FDC=2
R0 2 4 16727.1 L=3.5e-05 W=5e-07 $[rnpolym] $SUB=3 $X=0 $Y=0 $dt=2
R1 1 4 16727.1 L=3.5e-05 W=5e-07 $[rnpolym] $SUB=3 $X=750 $Y=0 $dt=2
.ends rnpolym_CDNS_7833473550913

* +++++++++++++++++++++++++++++++++++++++++++++++++++++++++ *
* Sub cell: rnpolym_CDNS_7833473550915                      *
* +++++++++++++++++++++++++++++++++++++++++++++++++++++++++ *
.subckt rnpolym_CDNS_7833473550915 1 2
** N=23 EP=2 FDC=22
R0 1 3 16727.1 L=3.5e-05 W=5e-07 $[rnpolym] $SUB=2 $X=0 $Y=0 $dt=2
R1 4 3 16727.1 L=3.5e-05 W=5e-07 $[rnpolym] $SUB=2 $X=750 $Y=0 $dt=2
R2 4 5 16727.1 L=3.5e-05 W=5e-07 $[rnpolym] $SUB=2 $X=1500 $Y=0 $dt=2
R3 6 5 16727.1 L=3.5e-05 W=5e-07 $[rnpolym] $SUB=2 $X=2250 $Y=0 $dt=2
R4 6 7 16727.1 L=3.5e-05 W=5e-07 $[rnpolym] $SUB=2 $X=3000 $Y=0 $dt=2
R5 8 7 16727.1 L=3.5e-05 W=5e-07 $[rnpolym] $SUB=2 $X=3750 $Y=0 $dt=2
R6 8 9 16727.1 L=3.5e-05 W=5e-07 $[rnpolym] $SUB=2 $X=4500 $Y=0 $dt=2
R7 10 9 16727.1 L=3.5e-05 W=5e-07 $[rnpolym] $SUB=2 $X=5250 $Y=0 $dt=2
R8 10 11 16727.1 L=3.5e-05 W=5e-07 $[rnpolym] $SUB=2 $X=6000 $Y=0 $dt=2
R9 12 11 16727.1 L=3.5e-05 W=5e-07 $[rnpolym] $SUB=2 $X=6750 $Y=0 $dt=2
R10 12 13 16727.1 L=3.5e-05 W=5e-07 $[rnpolym] $SUB=2 $X=7500 $Y=0 $dt=2
R11 14 13 16727.1 L=3.5e-05 W=5e-07 $[rnpolym] $SUB=2 $X=8250 $Y=0 $dt=2
R12 14 15 16727.1 L=3.5e-05 W=5e-07 $[rnpolym] $SUB=2 $X=9000 $Y=0 $dt=2
R13 16 15 16727.1 L=3.5e-05 W=5e-07 $[rnpolym] $SUB=2 $X=9750 $Y=0 $dt=2
R14 16 17 16727.1 L=3.5e-05 W=5e-07 $[rnpolym] $SUB=2 $X=10500 $Y=0 $dt=2
R15 18 17 16727.1 L=3.5e-05 W=5e-07 $[rnpolym] $SUB=2 $X=11250 $Y=0 $dt=2
R16 18 19 16727.1 L=3.5e-05 W=5e-07 $[rnpolym] $SUB=2 $X=12000 $Y=0 $dt=2
R17 20 19 16727.1 L=3.5e-05 W=5e-07 $[rnpolym] $SUB=2 $X=12750 $Y=0 $dt=2
R18 20 21 16727.1 L=3.5e-05 W=5e-07 $[rnpolym] $SUB=2 $X=13500 $Y=0 $dt=2
R19 22 21 16727.1 L=3.5e-05 W=5e-07 $[rnpolym] $SUB=2 $X=14250 $Y=0 $dt=2
R20 22 23 16727.1 L=3.5e-05 W=5e-07 $[rnpolym] $SUB=2 $X=15000 $Y=0 $dt=2
R21 2 23 16727.1 L=3.5e-05 W=5e-07 $[rnpolym] $SUB=2 $X=15750 $Y=0 $dt=2
.ends rnpolym_CDNS_7833473550915

* +++++++++++++++++++++++++++++++++++++++++++++++++++++++++ *
* Sub cell: rnpolym_CDNS_7833473550916                      *
* +++++++++++++++++++++++++++++++++++++++++++++++++++++++++ *
.subckt rnpolym_CDNS_7833473550916 1 2 3
** N=3 EP=3 FDC=1
R0 1 2 16727.1 L=3.5e-05 W=5e-07 $[rnpolym] $SUB=3 $X=0 $Y=0 $dt=2
.ends rnpolym_CDNS_7833473550916

* +++++++++++++++++++++++++++++++++++++++++++++++++++++++++ *
* Sub cell: rnpolym_CDNS_7833473550917                      *
* +++++++++++++++++++++++++++++++++++++++++++++++++++++++++ *
.subckt rnpolym_CDNS_7833473550917 1 2 3
** N=6 EP=3 FDC=4
R0 2 4 16727.1 L=3.5e-05 W=5e-07 $[rnpolym] $SUB=3 $X=0 $Y=0 $dt=2
R1 5 4 16727.1 L=3.5e-05 W=5e-07 $[rnpolym] $SUB=3 $X=750 $Y=0 $dt=2
R2 5 6 16727.1 L=3.5e-05 W=5e-07 $[rnpolym] $SUB=3 $X=1500 $Y=0 $dt=2
R3 1 6 16727.1 L=3.5e-05 W=5e-07 $[rnpolym] $SUB=3 $X=2250 $Y=0 $dt=2
.ends rnpolym_CDNS_7833473550917

* +++++++++++++++++++++++++++++++++++++++++++++++++++++++++ *
* Sub cell: rnpolym_CDNS_7833473550918                      *
* +++++++++++++++++++++++++++++++++++++++++++++++++++++++++ *
.subckt rnpolym_CDNS_7833473550918 1 2 3
** N=3 EP=3 FDC=1
R0 1 2 16727.1 L=3.5e-05 W=5e-07 $[rnpolym] $SUB=3 $X=0 $Y=0 $dt=2
.ends rnpolym_CDNS_7833473550918

* +++++++++++++++++++++++++++++++++++++++++++++++++++++++++ *
* Sub cell: pmos1v2hvt_4_CDNS_7833473550919                 *
* +++++++++++++++++++++++++++++++++++++++++++++++++++++++++ *
.subckt pmos1v2hvt_4_CDNS_7833473550919 1 2 3 4
** N=5 EP=4 FDC=1
M0 3 1 2 4 pmos1v2hvt L=1e-06 W=1e-05 AD=3e-12 AS=3e-12 PD=1.06e-05 PS=1.06e-05 m=1 $X=0 $Y=0 $dt=1
.ends pmos1v2hvt_4_CDNS_7833473550919

* +++++++++++++++++++++++++++++++++++++++++++++++++++++++++ *
* Sub cell: mux8_1p_fL                                      *
* +++++++++++++++++++++++++++++++++++++++++++++++++++++++++ *
.subckt mux8_1p_fL A0 VDDA A1 A2 IN0 IN1 IN2 COM A3 A4
+ A5 IN3 IN4 IN5 A6 A7 IN6 IN7
** N=19 EP=18 FDC=8
X0 A0 IN0 COM VDDA pmos1v2hvt_4_CDNS_7833473550919 $T=825 940 0 0 $X=205 $Y=220
X1 A1 IN1 COM VDDA pmos1v2hvt_4_CDNS_7833473550919 $T=3065 940 0 0 $X=2445 $Y=220
X2 A2 IN2 COM VDDA pmos1v2hvt_4_CDNS_7833473550919 $T=5305 940 0 0 $X=4685 $Y=220
X3 A3 IN3 COM VDDA pmos1v2hvt_4_CDNS_7833473550919 $T=7545 940 0 0 $X=6925 $Y=220
X4 A4 IN4 COM VDDA pmos1v2hvt_4_CDNS_7833473550919 $T=9785 940 0 0 $X=9165 $Y=220
X5 A5 IN5 COM VDDA pmos1v2hvt_4_CDNS_7833473550919 $T=12025 940 0 0 $X=11405 $Y=220
X6 A6 IN6 COM VDDA pmos1v2hvt_4_CDNS_7833473550919 $T=14265 940 0 0 $X=13645 $Y=220
X7 A7 IN7 COM VDDA pmos1v2hvt_4_CDNS_7833473550919 $T=16505 940 0 0 $X=15885 $Y=220
.ends mux8_1p_fL

* +++++++++++++++++++++++++++++++++++++++++++++++++++++++++ *
* Sub cell: trim_res_rnpolyn_2_fL                           *
* +++++++++++++++++++++++++++++++++++++++++++++++++++++++++ *
.subckt trim_res_rnpolyn_2_fL P1 P2 GNDA
** N=4 EP=3 FDC=14
X24 P1 4 GNDA rnpolym_CDNS_7833473550916 $T=9255 745 0 0 $X=9005 $Y=5
X25 4 P2 GNDA rnpolym_CDNS_7833473550916 $T=10005 35745 1 0 $X=9755 $Y=5
R0 P1 P2 16727.1 L=3.5e-05 W=5e-07 $[rnpolym] $SUB=GNDA $X=255 $Y=745 $dt=2
R1 P1 P2 16727.1 L=3.5e-05 W=5e-07 $[rnpolym] $SUB=GNDA $X=1005 $Y=745 $dt=2
R2 P1 P2 16727.1 L=3.5e-05 W=5e-07 $[rnpolym] $SUB=GNDA $X=1755 $Y=745 $dt=2
R3 P1 P2 16727.1 L=3.5e-05 W=5e-07 $[rnpolym] $SUB=GNDA $X=2505 $Y=745 $dt=2
R4 P1 P2 16727.1 L=3.5e-05 W=5e-07 $[rnpolym] $SUB=GNDA $X=3255 $Y=745 $dt=2
R5 P1 P2 16727.1 L=3.5e-05 W=5e-07 $[rnpolym] $SUB=GNDA $X=4005 $Y=745 $dt=2
R6 P1 P2 16727.1 L=3.5e-05 W=5e-07 $[rnpolym] $SUB=GNDA $X=4755 $Y=745 $dt=2
R7 P1 P2 16727.1 L=3.5e-05 W=5e-07 $[rnpolym] $SUB=GNDA $X=5505 $Y=745 $dt=2
R8 P1 P2 16727.1 L=3.5e-05 W=5e-07 $[rnpolym] $SUB=GNDA $X=6255 $Y=745 $dt=2
R9 P1 P2 16727.1 L=3.5e-05 W=5e-07 $[rnpolym] $SUB=GNDA $X=7005 $Y=745 $dt=2
R10 P1 P2 16727.1 L=3.5e-05 W=5e-07 $[rnpolym] $SUB=GNDA $X=7755 $Y=745 $dt=2
R11 P1 P2 16727.1 L=3.5e-05 W=5e-07 $[rnpolym] $SUB=GNDA $X=8505 $Y=745 $dt=2
.ends trim_res_rnpolyn_2_fL

* +++++++++++++++++++++++++++++++++++++++++++++++++++++++++ *
* Sub cell: trim_res_array_rn_2_fL                          *
* +++++++++++++++++++++++++++++++++++++++++++++++++++++++++ *
.subckt trim_res_array_rn_2_fL GNDA SEL1 P1 SEL2 SEL3 SEL4 P2
** N=15 EP=7 FDC=196
X2 P1 SEL1 GNDA trim_res_rnpolyn_2_fL $T=5445 6855 0 0 $X=5450 $Y=6145
X3 SEL1 SEL2 GNDA trim_res_rnpolyn_2_fL $T=15945 6855 0 0 $X=15950 $Y=6145
X4 SEL2 SEL3 GNDA trim_res_rnpolyn_2_fL $T=26445 6855 0 0 $X=26450 $Y=6145
X5 SEL3 SEL4 GNDA trim_res_rnpolyn_2_fL $T=36945 6855 0 0 $X=36950 $Y=6145
X6 SEL4 9 GNDA trim_res_rnpolyn_2_fL $T=47445 6855 0 0 $X=47450 $Y=6145
X7 9 10 GNDA trim_res_rnpolyn_2_fL $T=57945 6855 0 0 $X=57950 $Y=6145
X8 10 11 GNDA trim_res_rnpolyn_2_fL $T=68445 6855 0 0 $X=68450 $Y=6145
X9 11 12 GNDA trim_res_rnpolyn_2_fL $T=78945 6855 0 0 $X=78950 $Y=6145
X10 12 13 GNDA trim_res_rnpolyn_2_fL $T=89445 6855 0 0 $X=89450 $Y=6145
X11 13 14 GNDA trim_res_rnpolyn_2_fL $T=99945 6855 0 0 $X=99950 $Y=6145
X12 14 15 GNDA trim_res_rnpolyn_2_fL $T=110445 6855 0 0 $X=110450 $Y=6145
X13 15 8 GNDA trim_res_rnpolyn_2_fL $T=120945 6855 0 0 $X=120950 $Y=6145
X14 P2 8 GNDA trim_res_rnpolyn_2_fL $T=142350 6855 1 180 $X=131595 $Y=6145
X15 P2 8 GNDA trim_res_rnpolyn_2_fL $T=142105 6855 0 0 $X=142110 $Y=6145
.ends trim_res_array_rn_2_fL

* +++++++++++++++++++++++++++++++++++++++++++++++++++++++++ *
* Sub cell: nmos1v2hvt_4_CDNS_7833473550923                 *
* +++++++++++++++++++++++++++++++++++++++++++++++++++++++++ *
.subckt nmos1v2hvt_4_CDNS_7833473550923 1 2 3 4
** N=4 EP=4 FDC=1
M0 3 1 2 4 nmos1v2hvt L=1e-06 W=1e-05 AD=3e-12 AS=3e-12 PD=1.06e-05 PS=1.06e-05 m=1 $X=0 $Y=0 $dt=0
.ends nmos1v2hvt_4_CDNS_7833473550923

* +++++++++++++++++++++++++++++++++++++++++++++++++++++++++ *
* Sub cell: mux8_1_fL                                       *
* +++++++++++++++++++++++++++++++++++++++++++++++++++++++++ *
.subckt mux8_1_fL A0 A1 GNDA IN0 IN1 COM A2 A3 IN2 IN3
+ A4 A5 IN4 IN5 A6 A7 IN6 IN7
** N=18 EP=18 FDC=8
X16 A0 COM IN0 GNDA nmos1v2hvt_4_CDNS_7833473550923 $T=1515 1315 0 0 $X=915 $Y=915
X17 A1 COM IN1 GNDA nmos1v2hvt_4_CDNS_7833473550923 $T=3715 1315 0 0 $X=3115 $Y=915
X18 A2 COM IN2 GNDA nmos1v2hvt_4_CDNS_7833473550923 $T=5915 1315 0 0 $X=5315 $Y=915
X19 A3 COM IN3 GNDA nmos1v2hvt_4_CDNS_7833473550923 $T=8115 1315 0 0 $X=7515 $Y=915
X20 A4 COM IN4 GNDA nmos1v2hvt_4_CDNS_7833473550923 $T=10315 1315 0 0 $X=9715 $Y=915
X21 A5 COM IN5 GNDA nmos1v2hvt_4_CDNS_7833473550923 $T=12515 1315 0 0 $X=11915 $Y=915
X22 A6 COM IN6 GNDA nmos1v2hvt_4_CDNS_7833473550923 $T=14715 1315 0 0 $X=14115 $Y=915
X23 A7 COM IN7 GNDA nmos1v2hvt_4_CDNS_7833473550923 $T=16915 1315 0 0 $X=16315 $Y=915
.ends mux8_1_fL

* +++++++++++++++++++++++++++++++++++++++++++++++++++++++++ *
* Sub cell: pmos1v2hvt_4_CDNS_7833473550925                 *
* +++++++++++++++++++++++++++++++++++++++++++++++++++++++++ *
.subckt pmos1v2hvt_4_CDNS_7833473550925 1 2 3
** N=4 EP=3 FDC=1
M0 1 1 2 3 pmos1v2hvt L=1e-06 W=1e-05 AD=3e-12 AS=3e-12 PD=1.06e-05 PS=1.06e-05 m=1 $X=0 $Y=0 $dt=1
.ends pmos1v2hvt_4_CDNS_7833473550925

* +++++++++++++++++++++++++++++++++++++++++++++++++++++++++ *
* Sub cell: IN2                                             *
* +++++++++++++++++++++++++++++++++++++++++++++++++++++++++ *
.subckt IN2 A Out VDD VSS
** N=4 EP=4 FDC=2
M0 Out A VSS VSS nmos1v2hvt L=1.8e-07 W=6e-07 AD=1.8e-13 AS=1.8e-13 PD=1.2e-06 PS=1.2e-06 m=1 $X=375 $Y=390 $dt=0
M1 Out A VDD VDD pmos1v2hvt L=1.8e-07 W=9.4e-07 AD=2.82e-13 AS=2.82e-13 PD=1.54e-06 PS=1.54e-06 m=1 $X=375 $Y=1470 $dt=1
.ends IN2

* +++++++++++++++++++++++++++++++++++++++++++++++++++++++++ *
* Sub cell: inv8_fL                                         *
* +++++++++++++++++++++++++++++++++++++++++++++++++++++++++ *
.subckt inv8_fL OUT0 VDDA GNDA IN0 IN1 OUT2 IN2 OUT1 OUT3 IN3
+ IN5 OUT4 IN4 OUT6 IN6 OUT5 OUT7 IN7
** N=18 EP=18 FDC=16
X0 IN0 OUT0 VDDA GNDA IN2 $T=280 335 0 0 $X=55 $Y=85
X1 IN1 OUT1 VDDA GNDA IN2 $T=1480 335 0 0 $X=1255 $Y=85
X2 IN2 OUT2 VDDA GNDA IN2 $T=2680 335 0 0 $X=2455 $Y=85
X3 IN3 OUT3 VDDA GNDA IN2 $T=3880 335 0 0 $X=3655 $Y=85
X4 IN4 OUT4 VDDA GNDA IN2 $T=5080 335 0 0 $X=4855 $Y=85
X5 IN5 OUT5 VDDA GNDA IN2 $T=6280 335 0 0 $X=6055 $Y=85
X6 IN6 OUT6 VDDA GNDA IN2 $T=7480 335 0 0 $X=7255 $Y=85
X7 IN7 OUT7 VDDA GNDA IN2 $T=8680 335 0 0 $X=8455 $Y=85
.ends inv8_fL

* +++++++++++++++++++++++++++++++++++++++++++++++++++++++++ *
* Sub cell: pmos1v2hvt_4_CDNS_7833473550926                 *
* +++++++++++++++++++++++++++++++++++++++++++++++++++++++++ *
.subckt pmos1v2hvt_4_CDNS_7833473550926 1 2 3
** N=4 EP=3 FDC=1
M0 3 1 2 2 pmos1v2hvt L=1e-05 W=2.5e-05 AD=7.5e-12 AS=7.5e-12 PD=2.56e-05 PS=2.56e-05 m=1 $X=0 $Y=0 $dt=1
.ends pmos1v2hvt_4_CDNS_7833473550926

* +++++++++++++++++++++++++++++++++++++++++++++++++++++++++ *
* Sub cell: rnpolym_CDNS_7833473550931                      *
* +++++++++++++++++++++++++++++++++++++++++++++++++++++++++ *
.subckt rnpolym_CDNS_7833473550931 1
** N=8 EP=1 FDC=8
R0 1 2 16727.1 L=3.5e-05 W=5e-07 $[rnpolym] $SUB=1 $X=0 $Y=0 $dt=2
R1 3 2 16727.1 L=3.5e-05 W=5e-07 $[rnpolym] $SUB=1 $X=750 $Y=0 $dt=2
R2 3 4 16727.1 L=3.5e-05 W=5e-07 $[rnpolym] $SUB=1 $X=1500 $Y=0 $dt=2
R3 5 4 16727.1 L=3.5e-05 W=5e-07 $[rnpolym] $SUB=1 $X=2250 $Y=0 $dt=2
R4 5 6 16727.1 L=3.5e-05 W=5e-07 $[rnpolym] $SUB=1 $X=3000 $Y=0 $dt=2
R5 7 6 16727.1 L=3.5e-05 W=5e-07 $[rnpolym] $SUB=1 $X=3750 $Y=0 $dt=2
R6 7 8 16727.1 L=3.5e-05 W=5e-07 $[rnpolym] $SUB=1 $X=4500 $Y=0 $dt=2
R7 1 8 16727.1 L=3.5e-05 W=5e-07 $[rnpolym] $SUB=1 $X=5250 $Y=0 $dt=2
.ends rnpolym_CDNS_7833473550931

* +++++++++++++++++++++++++++++++++++++++++++++++++++++++++ *
* Sub cell: nmos1v2hvt_4_CDNS_7833473550932                 *
* +++++++++++++++++++++++++++++++++++++++++++++++++++++++++ *
.subckt nmos1v2hvt_4_CDNS_7833473550932 1 2 3
** N=3 EP=3 FDC=1
M0 3 1 2 2 nmos1v2hvt L=4e-06 W=8e-06 AD=2.4e-12 AS=2.4e-12 PD=8.6e-06 PS=8.6e-06 m=1 $X=0 $Y=0 $dt=0
.ends nmos1v2hvt_4_CDNS_7833473550932

* +++++++++++++++++++++++++++++++++++++++++++++++++++++++++ *
* Sub cell: pmos1v2hvt_4_CDNS_7833473550941                 *
* +++++++++++++++++++++++++++++++++++++++++++++++++++++++++ *
.subckt pmos1v2hvt_4_CDNS_7833473550941 1
** N=2 EP=1 FDC=1
M0 1 1 1 1 pmos1v2hvt L=2e-06 W=2.5e-05 AD=7.5e-12 AS=7.5e-12 PD=2.56e-05 PS=2.56e-05 m=1 $X=0 $Y=0 $dt=1
.ends pmos1v2hvt_4_CDNS_7833473550941

* +++++++++++++++++++++++++++++++++++++++++++++++++++++++++ *
* Sub cell: nmos1v2hvt_4_CDNS_7833473550942                 *
* +++++++++++++++++++++++++++++++++++++++++++++++++++++++++ *
.subckt nmos1v2hvt_4_CDNS_7833473550942 1 2 3 4
** N=4 EP=4 FDC=2
M0 4 1 2 3 nmos1v2hvt L=4e-06 W=8e-06 AD=2.72e-12 AS=2.4e-12 PD=8.68e-06 PS=8.6e-06 m=1 $X=0 $Y=0 $dt=0
M1 2 1 4 3 nmos1v2hvt L=4e-06 W=8e-06 AD=2.4e-12 AS=2.72e-12 PD=8.6e-06 PS=8.68e-06 m=1 $X=4340 $Y=0 $dt=0
.ends nmos1v2hvt_4_CDNS_7833473550942

* +++++++++++++++++++++++++++++++++++++++++++++++++++++++++ *
* Sub cell: rnpolym_CDNS_7833473550945                      *
* +++++++++++++++++++++++++++++++++++++++++++++++++++++++++ *
.subckt rnpolym_CDNS_7833473550945 1
** N=1 EP=1 FDC=1
R0 1 1 16727.1 L=3.5e-05 W=5e-07 $[rnpolym] $SUB=1 $X=0 $Y=0 $dt=2
.ends rnpolym_CDNS_7833473550945

* +++++++++++++++++++++++++++++++++++++++++++++++++++++++++ *
* Sub cell: pmos1v2hvt_4_CDNS_7833473550946                 *
* +++++++++++++++++++++++++++++++++++++++++++++++++++++++++ *
.subckt pmos1v2hvt_4_CDNS_7833473550946 1 2 3 4
** N=5 EP=4 FDC=4
M0 3 1 2 4 pmos1v2hvt L=2e-06 W=1e-05 AD=3.4e-12 AS=3e-12 PD=1.068e-05 PS=1.06e-05 m=1 $X=0 $Y=0 $dt=1
M1 2 1 3 4 pmos1v2hvt L=2e-06 W=1e-05 AD=3.4e-12 AS=3.4e-12 PD=1.068e-05 PS=1.068e-05 m=1 $X=2340 $Y=0 $dt=1
M2 3 1 2 4 pmos1v2hvt L=2e-06 W=1e-05 AD=3.4e-12 AS=3.4e-12 PD=1.068e-05 PS=1.068e-05 m=1 $X=4680 $Y=0 $dt=1
M3 2 1 3 4 pmos1v2hvt L=2e-06 W=1e-05 AD=3e-12 AS=3.4e-12 PD=1.06e-05 PS=1.068e-05 m=1 $X=7020 $Y=0 $dt=1
.ends pmos1v2hvt_4_CDNS_7833473550946

* +++++++++++++++++++++++++++++++++++++++++++++++++++++++++ *
* Sub cell: pmos1v2hvt_4_CDNS_7833473550949                 *
* +++++++++++++++++++++++++++++++++++++++++++++++++++++++++ *
.subckt pmos1v2hvt_4_CDNS_7833473550949 1 2 3 4
** N=5 EP=4 FDC=1
M0 3 1 2 4 pmos1v2hvt L=2e-06 W=1e-05 AD=3e-12 AS=3e-12 PD=1.06e-05 PS=1.06e-05 m=1 $X=0 $Y=0 $dt=1
.ends pmos1v2hvt_4_CDNS_7833473550949

* +++++++++++++++++++++++++++++++++++++++++++++++++++++++++ *
* Sub cell: pmos1v2hvt_4_CDNS_7833473550951                 *
* +++++++++++++++++++++++++++++++++++++++++++++++++++++++++ *
.subckt pmos1v2hvt_4_CDNS_7833473550951 1 2 3 4
** N=5 EP=4 FDC=4
M0 3 1 2 4 pmos1v2hvt L=2e-06 W=1e-05 AD=3.4e-12 AS=3e-12 PD=1.068e-05 PS=1.06e-05 m=1 $X=0 $Y=0 $dt=1
M1 2 1 3 4 pmos1v2hvt L=2e-06 W=1e-05 AD=3.4e-12 AS=3.4e-12 PD=1.068e-05 PS=1.068e-05 m=1 $X=2340 $Y=0 $dt=1
M2 3 1 2 4 pmos1v2hvt L=2e-06 W=1e-05 AD=3.4e-12 AS=3.4e-12 PD=1.068e-05 PS=1.068e-05 m=1 $X=4680 $Y=0 $dt=1
M3 2 1 3 4 pmos1v2hvt L=2e-06 W=1e-05 AD=3e-12 AS=3.4e-12 PD=1.06e-05 PS=1.068e-05 m=1 $X=7020 $Y=0 $dt=1
.ends pmos1v2hvt_4_CDNS_7833473550951

* +++++++++++++++++++++++++++++++++++++++++++++++++++++++++ *
* Sub cell: nmos1v2hvt_4_CDNS_7833473550937                 *
* +++++++++++++++++++++++++++++++++++++++++++++++++++++++++ *
.subckt nmos1v2hvt_4_CDNS_7833473550937 1 2 3 4
** N=4 EP=4 FDC=1
M0 3 1 2 4 nmos1v2hvt L=2e-06 W=1.875e-05 AD=5.625e-12 AS=5.625e-12 PD=1.935e-05 PS=1.935e-05 m=1 $X=0 $Y=0 $dt=0
.ends nmos1v2hvt_4_CDNS_7833473550937

* +++++++++++++++++++++++++++++++++++++++++++++++++++++++++ *
* Sub cell: MASCO__A3                                       *
* +++++++++++++++++++++++++++++++++++++++++++++++++++++++++ *
.subckt MASCO__A3 1 2 3 4 5 6 7
** N=7 EP=7 FDC=2
X0 1 5 4 3 nmos1v2hvt_4_CDNS_7833473550937 $T=620 19150 1 0 $X=0 $Y=0
X1 2 7 6 3 nmos1v2hvt_4_CDNS_7833473550937 $T=3860 19150 1 0 $X=3240 $Y=0
.ends MASCO__A3

* +++++++++++++++++++++++++++++++++++++++++++++++++++++++++ *
* Sub cell: MASCO__A4                                       *
* +++++++++++++++++++++++++++++++++++++++++++++++++++++++++ *
.subckt MASCO__A4 1 2 3 5 6 7 8
** N=8 EP=7 FDC=2
X0 1 6 5 3 nmos1v2hvt_4_CDNS_7833473550937 $T=620 720 0 0 $X=0 $Y=0
X1 2 8 7 3 nmos1v2hvt_4_CDNS_7833473550937 $T=3860 720 0 0 $X=3240 $Y=0
.ends MASCO__A4

* +++++++++++++++++++++++++++++++++++++++++++++++++++++++++ *
* Sub cell: MASCO__A1                                       *
* +++++++++++++++++++++++++++++++++++++++++++++++++++++++++ *
.subckt MASCO__A1 1 2 3 4 5
** N=6 EP=5 FDC=2
X0 1 2 3 2 pmos1v2hvt_4_CDNS_783347355090 $T=620 10400 1 0 $X=0 $Y=0
X1 4 2 5 2 pmos1v2hvt_4_CDNS_783347355090 $T=3860 10400 1 0 $X=3240 $Y=0
.ends MASCO__A1

* +++++++++++++++++++++++++++++++++++++++++++++++++++++++++ *
* Sub cell: MASCO__A5                                       *
* +++++++++++++++++++++++++++++++++++++++++++++++++++++++++ *
.subckt MASCO__A5 1 2 3 4 5 6 7 8
** N=9 EP=8 FDC=4
X0 2 3 7 1 4 MASCO__A1 $T=0 0 0 0 $X=0 $Y=0
X1 1 3 6 5 8 MASCO__A1 $T=6480 0 0 0 $X=6480 $Y=0
.ends MASCO__A5

* +++++++++++++++++++++++++++++++++++++++++++++++++++++++++ *
* Sub cell: MASCO__A6                                       *
* +++++++++++++++++++++++++++++++++++++++++++++++++++++++++ *
.subckt MASCO__A6 1 2 3 4 5 6 7 8 9
** N=9 EP=9 FDC=4
X0 1 2 3 8 9 5 4 MASCO__A3 $T=0 0 0 0 $X=0 $Y=0
X1 6 2 3 7 4 5 4 MASCO__A3 $T=6480 0 0 0 $X=6480 $Y=0
.ends MASCO__A6

* +++++++++++++++++++++++++++++++++++++++++++++++++++++++++ *
* Sub cell: MASCO__A7                                       *
* +++++++++++++++++++++++++++++++++++++++++++++++++++++++++ *
.subckt MASCO__A7 1 2 3 4 5 6 7 8 9
** N=9 EP=9 FDC=4
X0 1 2 3 8 9 5 4 MASCO__A4 $T=0 0 0 0 $X=0 $Y=0
X1 6 2 3 7 4 5 4 MASCO__A4 $T=6480 0 0 0 $X=6480 $Y=0
.ends MASCO__A7

* +++++++++++++++++++++++++++++++++++++++++++++++++++++++++ *
* Sub cell: MASCO__A8                                       *
* +++++++++++++++++++++++++++++++++++++++++++++++++++++++++ *
.subckt MASCO__A8 1 2 3 4 5 6 7 8 9 10
+ 11
** N=12 EP=11 FDC=8
X0 1 2 3 4 1 5 11 6 MASCO__A5 $T=0 0 0 0 $X=0 $Y=0
X1 1 1 3 8 1 9 7 10 MASCO__A5 $T=12960 0 0 0 $X=12960 $Y=0
.ends MASCO__A8

* +++++++++++++++++++++++++++++++++++++++++++++++++++++++++ *
* Sub cell: REF_V5_fLC                                      *
* +++++++++++++++++++++++++++++++++++++++++++++++++++++++++ *
.subckt REF_V5_fLC A0 A1 A2 A3 A4 A5 A6 A7 BG_REF BIAS
+ CJ_G1<0> CJ_G1<1> CJ_G1<2> CJ_G1<3> CJ_G1<4> CJ_G1<5> CJ_G2<0> CJ_G2<1> CJ_G2<2> CJ_G2<3>
+ CJ_G2<4> CJ_G2<5> CJ_G3<0> CJ_G3<1> CJ_G3<2> CJ_G3<3> CJ_G3<4> CJ_G3<5> CJ_G4<0> CJ_G4<1>
+ CJ_G4<2> CJ_G4<3> CJ_G4<4> CJ_G4<5> CL1X_1 CL4X_1 CL4X_2 EN GNDA Ib128nAT
+ LDO_REF LDO_SEL<0> LDO_SEL<1> LDO_SEL<2> LDO_SEL<3> LVDS_REF LVDS_SEL<0> LVDS_SEL<1> LVDS_SEL<2> LVDS_SEL<3>
+ LVDS_SEL<4> LVDS_SEL<5> LVDS_SEL<6> LVDS_SEL<7> V1000 V550 VDDA
** N=135 EP=57 FDC=768
X323 46 47 CL1X_1 VDDA pmos1v2hvt_4_CDNS_783347355090 $T=119265 106340 0 180 $X=116645 $Y=95940
X324 46 51 CJ_G1<1> VDDA pmos1v2hvt_4_CDNS_783347355090 $T=171105 106340 0 180 $X=168485 $Y=95940
X325 46 53 CJ_G1<2> VDDA pmos1v2hvt_4_CDNS_783347355090 $T=177585 106340 0 180 $X=174965 $Y=95940
X326 46 55 CJ_G1<3> VDDA pmos1v2hvt_4_CDNS_783347355090 $T=184065 106340 0 180 $X=181445 $Y=95940
X327 46 57 CJ_G1<4> VDDA pmos1v2hvt_4_CDNS_783347355090 $T=190545 106340 0 180 $X=187925 $Y=95940
X328 46 59 CJ_G2<0> VDDA pmos1v2hvt_4_CDNS_783347355090 $T=222945 106340 0 180 $X=220325 $Y=95940
X329 46 61 CJ_G2<1> VDDA pmos1v2hvt_4_CDNS_783347355090 $T=229425 106340 0 180 $X=226805 $Y=95940
X330 46 63 CJ_G2<2> VDDA pmos1v2hvt_4_CDNS_783347355090 $T=235905 106340 0 180 $X=233285 $Y=95940
X331 46 65 CJ_G2<3> VDDA pmos1v2hvt_4_CDNS_783347355090 $T=242385 106340 0 180 $X=239765 $Y=95940
X332 46 67 CJ_G2<4> VDDA pmos1v2hvt_4_CDNS_783347355090 $T=248865 106340 0 180 $X=246245 $Y=95940
X333 46 69 CJ_G3<0> VDDA pmos1v2hvt_4_CDNS_783347355090 $T=281265 106340 0 180 $X=278645 $Y=95940
X334 46 71 CJ_G3<1> VDDA pmos1v2hvt_4_CDNS_783347355090 $T=287745 106340 0 180 $X=285125 $Y=95940
X335 46 73 CJ_G3<2> VDDA pmos1v2hvt_4_CDNS_783347355090 $T=294225 106340 0 180 $X=291605 $Y=95940
X336 46 75 CJ_G3<3> VDDA pmos1v2hvt_4_CDNS_783347355090 $T=300705 106340 0 180 $X=298085 $Y=95940
X337 46 77 CJ_G3<4> VDDA pmos1v2hvt_4_CDNS_783347355090 $T=307185 106340 0 180 $X=304565 $Y=95940
X338 46 79 CJ_G4<0> VDDA pmos1v2hvt_4_CDNS_783347355090 $T=329865 106340 0 180 $X=327245 $Y=95940
X339 46 81 CJ_G4<1> VDDA pmos1v2hvt_4_CDNS_783347355090 $T=336345 106340 0 180 $X=333725 $Y=95940
X340 46 83 CJ_G4<2> VDDA pmos1v2hvt_4_CDNS_783347355090 $T=342825 106340 0 180 $X=340205 $Y=95940
X341 46 85 CJ_G4<3> VDDA pmos1v2hvt_4_CDNS_783347355090 $T=349305 106340 0 180 $X=346685 $Y=95940
X342 46 87 CJ_G4<4> VDDA pmos1v2hvt_4_CDNS_783347355090 $T=355785 106340 0 180 $X=353165 $Y=95940
X343 89 VDDA pmos1v2hvt_4_CDNS_783347355095 $T=103985 118460 1 0 $X=103365 $Y=108060
X344 EN GNDA GNDA 17 nmos1v2hvt_4_CDNS_783347355098 $T=5090 25775 0 0 $X=4470 $Y=25055
X345 17 GNDA GNDA 18 nmos1v2hvt_4_CDNS_783347355098 $T=6830 25775 0 0 $X=6210 $Y=25055
X346 17 GNDA GNDA 42 nmos1v2hvt_4_CDNS_783347355098 $T=9600 25775 0 0 $X=8980 $Y=25055
X347 18 42 GNDA BIAS nmos1v2hvt_4_CDNS_783347355098 $T=12075 25775 0 0 $X=11455 $Y=25055
X348 17 GNDA GNDA 19 nmos1v2hvt_4_CDNS_783347355098 $T=129135 6395 0 0 $X=128515 $Y=5675
X349 EN VDDA 17 pmos1v2hvt_4_CDNS_7833473550911 $T=5090 30735 1 0 $X=4470 $Y=28335
X350 18 VDDA 45 pmos1v2hvt_4_CDNS_7833473550911 $T=6135 60650 0 270 $X=5415 $Y=59530
X351 18 VDDA 41 pmos1v2hvt_4_CDNS_7833473550911 $T=6135 62390 0 270 $X=5415 $Y=61270
X352 17 VDDA 18 pmos1v2hvt_4_CDNS_7833473550911 $T=6830 30735 1 0 $X=6210 $Y=28335
X353 30 31 GNDA rnpolym_CDNS_7833473550913 $T=318935 44825 0 180 $X=317435 $Y=9085
X354 V550 GNDA rnpolym_CDNS_7833473550915 $T=317685 46225 0 0 $X=317435 $Y=45485
X355 30 29 GNDA rnpolym_CDNS_7833473550916 $T=316935 44825 1 0 $X=316685 $Y=9085
X356 28 V550 GNDA rnpolym_CDNS_7833473550916 $T=316935 81225 1 0 $X=316685 $Y=45485
X357 31 32 GNDA rnpolym_CDNS_7833473550917 $T=321935 44825 0 180 $X=318935 $Y=9085
X358 33 32 GNDA rnpolym_CDNS_7833473550918 $T=322185 9825 0 0 $X=321935 $Y=9085
X359 34 33 GNDA rnpolym_CDNS_7833473550918 $T=322935 44825 1 0 $X=322685 $Y=9085
X360 35 34 GNDA rnpolym_CDNS_7833473550918 $T=323685 9825 0 0 $X=323435 $Y=9085
X361 36 35 GNDA rnpolym_CDNS_7833473550918 $T=324435 44825 1 0 $X=324185 $Y=9085
X362 39 36 GNDA rnpolym_CDNS_7833473550918 $T=325185 9825 0 0 $X=324935 $Y=9085
X363 37 39 GNDA rnpolym_CDNS_7833473550918 $T=325935 44825 1 0 $X=325685 $Y=9085
X364 40 37 GNDA rnpolym_CDNS_7833473550918 $T=326685 9825 0 0 $X=326435 $Y=9085
X365 V1000 40 GNDA rnpolym_CDNS_7833473550918 $T=327435 44825 1 0 $X=327185 $Y=9085
X366 5 VDDA 6 7 31 32 36 LDO_REF 9 VDDA
+ VDDA V1000 VDDA VDDA VDDA VDDA VDDA VDDA mux8_1p_fL $T=349200 25815 0 90 $X=337860 $Y=26020
X367 15 VDDA 14 13 33 34 35 LVDS_REF 12 11
+ 10 36 39 37 8 93 40 30 mux8_1p_fL $T=350670 58240 0 90 $X=339330 $Y=58445
X368 GNDA 21 20 23 25 27 29 trim_res_array_rn_2_fL $T=164075 2225 0 0 $X=169525 $Y=8370
X369 GNDA 22 20 24 26 94 28 trim_res_array_rn_2_fL $T=164075 88825 1 0 $X=169525 $Y=45485
X370 A0 A1 GNDA 26 24 1 A2 A3 22 20
+ A4 A5 21 23 A6 A7 25 27 mux8_1_fL $T=154225 54940 0 270 $X=154225 $Y=35510
X371 46 89 VDDA pmos1v2hvt_4_CDNS_7833473550925 $T=107545 106340 1 0 $X=106925 $Y=95940
X372 5 VDDA GNDA LDO_SEL<0> LDO_SEL<1> 7 LDO_SEL<2> 6 9 LDO_SEL<3>
+ GNDA 107 GNDA 108 GNDA 109 110 GNDA inv8_fL $T=337805 19035 0 0 $X=337860 $Y=19120
X373 15 VDDA GNDA LVDS_SEL<0> LVDS_SEL<1> 13 LVDS_SEL<2> 14 12 LVDS_SEL<3>
+ LVDS_SEL<5> 11 LVDS_SEL<4> 8 LVDS_SEL<6> 10 93 LVDS_SEL<7> inv8_fL $T=349595 50170 1 180 $X=339490 $Y=50255
X374 45 VDDA 41 pmos1v2hvt_4_CDNS_7833473550926 $T=8900 66955 0 0 $X=8280 $Y=66235
X375 45 VDDA 45 pmos1v2hvt_4_CDNS_7833473550926 $T=8900 118460 1 0 $X=8280 $Y=93060
X376 45 VDDA 45 pmos1v2hvt_4_CDNS_7833473550926 $T=20140 66955 0 0 $X=19520 $Y=66235
X377 45 VDDA 41 pmos1v2hvt_4_CDNS_7833473550926 $T=20140 118460 1 0 $X=19520 $Y=93060
X378 45 VDDA 41 pmos1v2hvt_4_CDNS_7833473550926 $T=31380 66955 0 0 $X=30760 $Y=66235
X379 45 VDDA 45 pmos1v2hvt_4_CDNS_7833473550926 $T=31380 118460 1 0 $X=30760 $Y=93060
X380 45 VDDA 45 pmos1v2hvt_4_CDNS_7833473550926 $T=42620 66955 0 0 $X=42000 $Y=66235
X381 45 VDDA 41 pmos1v2hvt_4_CDNS_7833473550926 $T=42620 118460 1 0 $X=42000 $Y=93060
X382 45 VDDA 45 pmos1v2hvt_4_CDNS_7833473550926 $T=63860 66955 1 180 $X=53240 $Y=66235
X383 45 VDDA 41 pmos1v2hvt_4_CDNS_7833473550926 $T=63860 118460 0 180 $X=53240 $Y=93060
X384 45 VDDA 41 pmos1v2hvt_4_CDNS_7833473550926 $T=75100 66955 1 180 $X=64480 $Y=66235
X385 45 VDDA 45 pmos1v2hvt_4_CDNS_7833473550926 $T=75100 118460 0 180 $X=64480 $Y=93060
X386 45 VDDA 45 pmos1v2hvt_4_CDNS_7833473550926 $T=86340 66955 1 180 $X=75720 $Y=66235
X387 45 VDDA 41 pmos1v2hvt_4_CDNS_7833473550926 $T=86340 118460 0 180 $X=75720 $Y=93060
X388 45 VDDA 41 pmos1v2hvt_4_CDNS_7833473550926 $T=97580 66955 1 180 $X=86960 $Y=66235
X389 45 VDDA 45 pmos1v2hvt_4_CDNS_7833473550926 $T=97580 118460 0 180 $X=86960 $Y=93060
X390 41 V1000 V1000 pmos1v2hvt_4_CDNS_7833473550926 $T=120470 66660 0 0 $X=119850 $Y=65940
X391 41 V1000 V1000 pmos1v2hvt_4_CDNS_7833473550926 $T=131710 66660 0 0 $X=131090 $Y=65940
X392 41 V1000 V1000 pmos1v2hvt_4_CDNS_7833473550926 $T=142950 66660 0 0 $X=142330 $Y=65940
X393 41 V1000 V1000 pmos1v2hvt_4_CDNS_7833473550926 $T=154190 66660 0 0 $X=153570 $Y=65940
X394 41 V1000 V1000 pmos1v2hvt_4_CDNS_7833473550926 $T=360735 9955 0 0 $X=360115 $Y=9235
X395 41 V1000 V1000 pmos1v2hvt_4_CDNS_7833473550926 $T=360735 36075 0 0 $X=360115 $Y=35355
X396 41 V1000 V1000 pmos1v2hvt_4_CDNS_7833473550926 $T=360735 62195 0 0 $X=360115 $Y=61475
X397 41 V1000 V1000 pmos1v2hvt_4_CDNS_7833473550926 $T=371975 9955 0 0 $X=371355 $Y=9235
X398 41 V1000 V1000 pmos1v2hvt_4_CDNS_7833473550926 $T=371975 36075 0 0 $X=371355 $Y=35355
X399 41 V1000 V1000 pmos1v2hvt_4_CDNS_7833473550926 $T=371975 62195 0 0 $X=371355 $Y=61475
X400 41 V1000 V1000 pmos1v2hvt_4_CDNS_7833473550926 $T=383215 36075 0 0 $X=382595 $Y=35355
X401 41 V1000 V1000 pmos1v2hvt_4_CDNS_7833473550926 $T=383215 62195 0 0 $X=382595 $Y=61475
X402 41 V1000 V1000 pmos1v2hvt_4_CDNS_7833473550926 $T=394455 36075 0 0 $X=393835 $Y=35355
X403 41 V1000 V1000 pmos1v2hvt_4_CDNS_7833473550926 $T=394455 62195 0 0 $X=393835 $Y=61475
X404 41 V1000 V1000 pmos1v2hvt_4_CDNS_7833473550926 $T=405695 36075 0 0 $X=405075 $Y=35355
X405 41 V1000 V1000 pmos1v2hvt_4_CDNS_7833473550926 $T=405695 62195 0 0 $X=405075 $Y=61475
X406 GNDA rnpolym_CDNS_7833473550931 $T=328185 9825 0 0 $X=327935 $Y=9085
X407 42 GNDA 44 nmos1v2hvt_4_CDNS_7833473550932 $T=5090 6635 0 0 $X=4470 $Y=5915
X408 42 GNDA 42 nmos1v2hvt_4_CDNS_7833473550932 $T=5090 23885 1 0 $X=4470 $Y=15485
X409 42 GNDA 42 nmos1v2hvt_4_CDNS_7833473550932 $T=10330 6635 0 0 $X=9710 $Y=5915
X410 42 GNDA 44 nmos1v2hvt_4_CDNS_7833473550932 $T=10330 23885 1 0 $X=9710 $Y=15485
X411 19 GNDA 119 nmos1v2hvt_4_CDNS_7833473550932 $T=134790 6635 0 0 $X=134170 $Y=5915
X412 19 GNDA 19 nmos1v2hvt_4_CDNS_7833473550932 $T=134790 23885 1 0 $X=134170 $Y=15485
X413 19 GNDA 19 nmos1v2hvt_4_CDNS_7833473550932 $T=140030 6635 0 0 $X=139410 $Y=5915
X414 19 GNDA 119 nmos1v2hvt_4_CDNS_7833473550932 $T=140030 23885 1 0 $X=139410 $Y=15485
X415 VDDA pmos1v2hvt_4_CDNS_7833473550941 $T=5660 66955 0 0 $X=5040 $Y=66235
X416 VDDA pmos1v2hvt_4_CDNS_7833473550941 $T=5660 118460 1 0 $X=5040 $Y=93060
X417 VDDA pmos1v2hvt_4_CDNS_7833473550941 $T=98820 66955 0 0 $X=98200 $Y=66235
X418 VDDA pmos1v2hvt_4_CDNS_7833473550941 $T=98820 118460 1 0 $X=98200 $Y=93060
X419 3 19 GNDA 3 nmos1v2hvt_4_CDNS_7833473550942 $T=134790 26320 0 0 $X=134170 $Y=25600
X420 4 3 GNDA 4 nmos1v2hvt_4_CDNS_7833473550942 $T=134790 36805 0 0 $X=134170 $Y=36085
X421 3 119 GNDA 46 nmos1v2hvt_4_CDNS_7833473550942 $T=144370 26320 0 0 $X=143750 $Y=25600
X422 GNDA rnpolym_CDNS_7833473550945 $T=169025 9825 0 0 $X=168775 $Y=9085
X423 GNDA rnpolym_CDNS_7833473550945 $T=169025 46225 0 0 $X=168775 $Y=45485
X424 GNDA rnpolym_CDNS_7833473550945 $T=334185 9825 0 0 $X=333935 $Y=9085
X425 GNDA rnpolym_CDNS_7833473550945 $T=334185 46225 0 0 $X=333935 $Y=45485
X426 46 120 CL4X_1 VDDA pmos1v2hvt_4_CDNS_7833473550946 $T=132565 106340 1 0 $X=131945 $Y=95930
X427 46 122 CL4X_2 VDDA pmos1v2hvt_4_CDNS_7833473550946 $T=148765 106340 1 0 $X=148145 $Y=95930
X428 46 124 CJ_G1<0> VDDA pmos1v2hvt_4_CDNS_7833473550949 $T=164625 106340 0 180 $X=162005 $Y=95940
X429 46 126 CJ_G1<5> VDDA pmos1v2hvt_4_CDNS_7833473550951 $T=197365 106340 1 0 $X=196745 $Y=95930
X430 46 128 CJ_G2<5> VDDA pmos1v2hvt_4_CDNS_7833473550951 $T=260010 106340 1 0 $X=259390 $Y=95930
X431 46 130 CJ_G3<5> VDDA pmos1v2hvt_4_CDNS_7833473550951 $T=314365 106340 1 0 $X=313745 $Y=95930
X432 46 132 CJ_G4<5> VDDA pmos1v2hvt_4_CDNS_7833473550951 $T=362605 106340 1 0 $X=361985 $Y=95930
X433 46 134 Ib128nAT VDDA pmos1v2hvt_4_CDNS_7833473550951 $T=378805 106340 1 0 $X=378185 $Y=95930
X434 1 GNDA GNDA 45 44 GNDA GNDA MASCO__A3 $T=122745 36240 0 0 $X=122745 $Y=36240
X435 BG_REF GNDA GNDA 41 44 GNDA GNDA MASCO__A4 $T=122745 14720 0 0 $X=122745 $Y=14720
X436 41 41 VDDA V1000 VDDA V1000 V1000 VDDA MASCO__A5 $T=392045 108060 0 0 $X=392045 $Y=108060
X437 GNDA 1 GNDA 44 45 BG_REF 41 GNDA GNDA MASCO__A6 $T=19065 36240 0 0 $X=19065 $Y=36240
X438 BG_REF 1 GNDA 44 45 BG_REF 41 41 44 MASCO__A6 $T=32025 36240 0 0 $X=32025 $Y=36240
X439 BG_REF 1 GNDA 44 45 BG_REF 41 41 44 MASCO__A6 $T=44985 36240 0 0 $X=44985 $Y=36240
X440 BG_REF 1 GNDA 44 45 BG_REF 41 41 44 MASCO__A6 $T=57945 36240 0 0 $X=57945 $Y=36240
X441 BG_REF BG_REF GNDA 44 41 1 45 41 44 MASCO__A6 $T=70905 36240 0 0 $X=70905 $Y=36240
X442 1 BG_REF GNDA 44 41 1 45 45 44 MASCO__A6 $T=83865 36240 0 0 $X=83865 $Y=36240
X443 1 BG_REF GNDA 44 41 1 45 45 44 MASCO__A6 $T=96825 36240 0 0 $X=96825 $Y=36240
X444 1 BG_REF GNDA 44 41 1 45 45 44 MASCO__A6 $T=109785 36240 0 0 $X=109785 $Y=36240
X445 GNDA BG_REF GNDA 44 41 1 45 GNDA GNDA MASCO__A7 $T=19065 14720 0 0 $X=19065 $Y=14720
X446 1 BG_REF GNDA 44 41 1 45 45 44 MASCO__A7 $T=32025 14720 0 0 $X=32025 $Y=14720
X447 1 BG_REF GNDA 44 41 1 45 45 44 MASCO__A7 $T=44985 14720 0 0 $X=44985 $Y=14720
X448 1 BG_REF GNDA 44 41 1 45 45 44 MASCO__A7 $T=57945 14720 0 0 $X=57945 $Y=14720
X449 1 1 GNDA 44 45 BG_REF 41 45 44 MASCO__A7 $T=70905 14720 0 0 $X=70905 $Y=14720
X450 BG_REF 1 GNDA 44 45 BG_REF 41 41 44 MASCO__A7 $T=83865 14720 0 0 $X=83865 $Y=14720
X451 BG_REF 1 GNDA 44 45 BG_REF 41 41 44 MASCO__A7 $T=96825 14720 0 0 $X=96825 $Y=14720
X452 BG_REF 1 GNDA 44 45 BG_REF 41 41 44 MASCO__A7 $T=109785 14720 0 0 $X=109785 $Y=14720
X453 41 VDDA VDDA V1000 4 47 V1000 V1000 V1000 120
+ VDDA MASCO__A8 $T=106925 108060 0 0 $X=106925 $Y=108060
X454 41 41 VDDA 120 120 V1000 122 122 122 122
+ 120 MASCO__A8 $T=132845 108060 0 0 $X=132845 $Y=108060
X455 41 41 VDDA 124 V1000 51 V1000 53 V1000 55
+ V1000 MASCO__A8 $T=158765 108060 0 0 $X=158765 $Y=108060
X456 41 41 VDDA 57 V1000 126 V1000 126 V1000 126
+ V1000 MASCO__A8 $T=184685 108060 0 0 $X=184685 $Y=108060
X457 41 41 VDDA 126 V1000 59 V1000 61 V1000 63
+ V1000 MASCO__A8 $T=210605 108060 0 0 $X=210605 $Y=108060
X458 41 41 VDDA 65 V1000 67 V1000 128 V1000 128
+ V1000 MASCO__A8 $T=236525 108060 0 0 $X=236525 $Y=108060
X459 41 41 VDDA 128 V1000 128 V1000 69 V1000 71
+ V1000 MASCO__A8 $T=262445 108060 0 0 $X=262445 $Y=108060
X460 41 41 VDDA 73 V1000 75 V1000 77 V1000 130
+ V1000 MASCO__A8 $T=288365 108060 0 0 $X=288365 $Y=108060
X461 41 41 VDDA 130 130 V1000 79 V1000 81 V1000
+ 130 MASCO__A8 $T=314285 108060 0 0 $X=314285 $Y=108060
X462 41 41 VDDA V1000 85 V1000 87 V1000 132 132
+ 83 MASCO__A8 $T=340205 108060 0 0 $X=340205 $Y=108060
X463 41 41 VDDA 132 V1000 134 134 134 134 V1000
+ 132 MASCO__A8 $T=366125 108060 0 0 $X=366125 $Y=108060
.ends REF_V5_fLC
