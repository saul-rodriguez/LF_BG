* +++++++++++++++++++++++++++++++++++++++++++++++++++++++++ *
* CDL Netlist:                                              *
*                                                           *
* Cell Name  : mux8_1p_fL                                   *
* Netlisted  : Thu Jun 25 14:27:37 2026                     *
* PVS Version: 24.11-s045 Mon Jan 27 22:18:54 PST 2025      *
* +++++++++++++++++++++++++++++++++++++++++++++++++++++++++ *
*.LDD
*.DEVTMPLT 0 MP(pmos1v2hvt) PMOS1V2HVT PDIFF(D) PGATE(G) PDIFF(S) NW1V2(B)

* +++++++++++++++++++++++++++++++++++++++++++++++++++++++++ *
* Sub cell: Contact_CDNS_782397654261                       *
* +++++++++++++++++++++++++++++++++++++++++++++++++++++++++ *
.subckt Contact_CDNS_782397654261 1 2
** N=2 EP=2 FDC=0
.ends Contact_CDNS_782397654261

* +++++++++++++++++++++++++++++++++++++++++++++++++++++++++ *
* Sub cell: Contact_CDNS_782397654262                       *
* +++++++++++++++++++++++++++++++++++++++++++++++++++++++++ *
.subckt Contact_CDNS_782397654262 1
** N=1 EP=1 FDC=0
.ends Contact_CDNS_782397654262

* +++++++++++++++++++++++++++++++++++++++++++++++++++++++++ *
* Sub cell: pmos1v2hvt_4_CDNS_782397654260                  *
* +++++++++++++++++++++++++++++++++++++++++++++++++++++++++ *
.subckt pmos1v2hvt_4_CDNS_782397654260 1 2 3 4 5
** N=5 EP=5 FDC=1
X0 2 3 Contact_CDNS_782397654261 $T=-245 130 0 0 $X=-245 $Y=0
X1 2 4 Contact_CDNS_782397654261 $T=1095 130 0 0 $X=1095 $Y=0
X2 3 Contact_CDNS_782397654262 $T=-275 140 0 0 $X=-275 $Y=0
X3 4 Contact_CDNS_782397654262 $T=1065 140 0 0 $X=1065 $Y=0
M0 4 1 3 5 pmos1v2hvt L=1e-06 W=1e-05 AD=3e-12 AS=3e-12 PD=1.06e-05 PS=1.06e-05 m=1 $X=0 $Y=0 $dt=0
.ends pmos1v2hvt_4_CDNS_782397654260

* +++++++++++++++++++++++++++++++++++++++++++++++++++++++++ *
* Sub cell: mux8_1p_fL                                      *
* +++++++++++++++++++++++++++++++++++++++++++++++++++++++++ *
.subckt mux8_1p_fL 1 6 8 10 12 14 16 18 4 3
+ 7 9 11 13 15 17 19 5
** N=20 EP=18 FDC=8
X0 1 2 3 4 5 pmos1v2hvt_4_CDNS_782397654260 $T=825 940 0 0 $X=205 $Y=220
X1 6 2 7 4 5 pmos1v2hvt_4_CDNS_782397654260 $T=3065 940 0 0 $X=2445 $Y=220
X2 8 2 9 4 5 pmos1v2hvt_4_CDNS_782397654260 $T=5305 940 0 0 $X=4685 $Y=220
X3 10 2 11 4 5 pmos1v2hvt_4_CDNS_782397654260 $T=7545 940 0 0 $X=6925 $Y=220
X4 12 2 13 4 5 pmos1v2hvt_4_CDNS_782397654260 $T=9785 940 0 0 $X=9165 $Y=220
X5 14 2 15 4 5 pmos1v2hvt_4_CDNS_782397654260 $T=12025 940 0 0 $X=11405 $Y=220
X6 16 2 17 4 5 pmos1v2hvt_4_CDNS_782397654260 $T=14265 940 0 0 $X=13645 $Y=220
X7 18 2 19 4 5 pmos1v2hvt_4_CDNS_782397654260 $T=16505 940 0 0 $X=15885 $Y=220
.ends mux8_1p_fL
