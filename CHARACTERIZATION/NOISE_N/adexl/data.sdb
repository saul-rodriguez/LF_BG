ADE simulation setup
Run mode: Single Run, Sweeps and Corners
Tests:
  CHARACTERIZATION:NOISE_N:1: CHARACTERIZATION/NOISE_N/schematic, simulator spectre
Global variables:
  IDS1 = 10n,100n,1u,10u,100u
  L1 = 1u
  NF1 = 4
  VDS1 = 0.6
  W1 = 32u
  LF1 = 1u
  WF1 = 8u
