ADE simulation setup
Run mode: Monte Carlo Sampling
Tests:
  Corner_test (off): TEST/test_mc/schematic, simulator spectre
    Outputs: VTH
  MC_test: TEST/test_mc/schematic, simulator spectre
    Outputs: VTH
Corners:
  model folders: /opt/pdk/lf11/PDK_LF11ISi_V1_3_2/analog/models/spectre
  C0: lf11is.scs[1v2hvt_ff 1v2hvt_ss 1v2hvt_sf  1v2hvt_fs]
Monte Carlo Sampling options: mcmethod=all, mcnumpoints=20, parasiticanalysis=0
