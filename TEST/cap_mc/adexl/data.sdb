ADE simulation setup
Run mode: Monte Carlo Sampling
Tests:
  TEST:cap_mc:1: TEST/cap_mc/schematic, simulator spectre
    Outputs: capacitance
Global variables:
  L = 4u
  W = 4u
Monte Carlo Sampling options: mcmethod=mismatch, mcnumpoints=200, parasiticanalysis=0
