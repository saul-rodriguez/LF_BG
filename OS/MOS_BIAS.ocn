simulator( 'spectre )

;design(	 "/home/saul/simulation/MOS_BIAS/spectre/schematic/netlist/netlist")
; resultsDir( "/home/saul/simulation/MOS_BIAS/spectre/schematic" )
design( "CHARACTERIZATION" "MOS_BIAS" "schematic")

modelFile(
    '("/pkg/lfoundry/PDK_LF11ISi_V1_3_2/PDK_LF11ISi_V1_3_2/analog/models/spectre/lf11is.scs" "1v2hvt_tt")
    '("/pkg/lfoundry/PDK_LF11ISi_V1_3_2/PDK_LF11ISi_V1_3_2/analog/models/spectre/lf11is.scs" "3v3rvt_tt")
    '("/pkg/lfoundry/PDK_LF11ISi_V1_3_2/PDK_LF11ISi_V1_3_2/analog/models/spectre/lf11is.scs" "res_typ")
    '("/pkg/lfoundry/PDK_LF11ISi_V1_3_2/PDK_LF11ISi_V1_3_2/analog/models/spectre/lf11is.scs" "bjt_typ")
    '("/pkg/lfoundry/PDK_LF11ISi_V1_3_2/PDK_LF11ISi_V1_3_2/analog/models/spectre/lf11is.scs" "dio_typ")
    '("/pkg/lfoundry/PDK_LF11ISi_V1_3_2/PDK_LF11ISi_V1_3_2/analog/models/spectre/lf11is.scs" "mim_typ")
    '("/pkg/lfoundry/PDK_LF11ISi_V1_3_2/PDK_LF11ISi_V1_3_2/analog/models/spectre/lf11is.scs" "cvnm2m3_typ")
    '("/pkg/lfoundry/PDK_LF11ISi_V1_3_2/PDK_LF11ISi_V1_3_2/analog/models/spectre/lf11is.scs" "cvnm2m4_typ")
    '("/pkg/lfoundry/PDK_LF11ISi_V1_3_2/PDK_LF11ISi_V1_3_2/analog/models/spectre/lf11is.scs" "nvar1v2hvt_typ")
    '("/pkg/lfoundry/PDK_LF11ISi_V1_3_2/PDK_LF11ISi_V1_3_2/analog/models/spectre/lf11is.scs" "nvar3v3rvt_typ")
)
analysis('dc ?saveOppoint t  )
desVar(	  "L1" 0.11u	)
desVar(	  "IDS1" 1u	)
desVar(	  "W1" 20u	)
desVar(	  "VDS1" 0.6	)
desVar(	  "NF1" 20	)
desVar(	  "IDS2" 2u	)
desVar(	  "L2" 220n	)
desVar(	  "NF2" 1	)
desVar(	  "VDS2" 0.5	)
desVar(	  "W2" 10u	)
envOption(
	'analysisOrder  list("dc")
)
temp( 27 )
run()
