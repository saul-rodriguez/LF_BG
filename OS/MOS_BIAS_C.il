simulator( 'spectre )
hostMode( 'distributed )

;design(	 "/home/saul/simulation/MOS_BIAS/spectre/schematic/netlist/netlist")
design( "CHARACTERIZATION" "MOS_BIAS" "schematic")
createNetlist

resultsDir( "/home/saul/simulation/MOS_BIAS/spectre/schematic" )

load( "OS/global.il" )

modelFile(
    '("/opt/pdk/lf11/PDK_LF11ISi_V1_3_2/analog/models/spectre/lf11is.scs" "1v2hvt_tt")
    '("/opt/pdk/lf11/PDK_LF11ISi_V1_3_2/analog/models/spectre/lf11is.scs" "3v3rvt_tt")
    '("/opt/pdk/lf11/PDK_LF11ISi_V1_3_2/analog/models/spectre/lf11is.scs" "res_typ")
    '("/opt/pdk/lf11/PDK_LF11ISi_V1_3_2/analog/models/spectre/lf11is.scs" "bjt_typ")
    '("/opt/pdk/lf11/PDK_LF11ISi_V1_3_2/analog/models/spectre/lf11is.scs" "dio_typ")
    '("/opt/pdk/lf11/PDK_LF11ISi_V1_3_2/analog/models/spectre/lf11is.scs" "mim_typ")
    '("/opt/pdk/lf11/PDK_LF11ISi_V1_3_2/analog/models/spectre/lf11is.scs" "cvnm2m3_typ")
    '("/opt/pdk/lf11/PDK_LF11ISi_V1_3_2/analog/models/spectre/lf11is.scs" "cvnm2m4_typ")
    '("/opt/pdk/lf11/PDK_LF11ISi_V1_3_2/analog/models/spectre/lf11is.scs" "nvar1v2hvt_typ")
    '("/opt/pdk/lf11/PDK_LF11ISi_V1_3_2/analog/models/spectre/lf11is.scs" "nvar3v3rvt_typ")
)
analysis('dc ?saveOppoint t  )
desVar(	  "IDS1" IDS1	)
desVar(	  "IDS2" IDS2	)
desVar(	  "L1" L1	)
desVar(	  "L2" L2	)
desVar(	  "NF1" NF1	)
desVar(	  "NF2" NF2	)
desVar(	  "VDS1" VDS1	)
desVar(	  "VDS2" VDS2	)
desVar(	  "WF1" WF1	)
desVar(	  "WF2" WF2	)
desVar(	  "W2" WF2*NF2	)
desVar(	  "W1" WF1*NF1	)
envOption(
	'analysisOrder  list("dc")
)
temp( 27 )
;run()

jobList = nil

; starting first job
jobList = append1( jobList run( ?host "950e82c38b16" ) )

; wait for all the jobs to complete
wait((append1 last(jobList) nil))

gm1 = pv("M0" "gm" ?result "dcOpInfo")
;plot( gm ?expr '( "gm1" ) )

cgs1 = 1e15*mag(pv("M0" "cgs" ?result "dcOpInfo"))
cgd1 = 1e15*mag(pv("M0" "cgd" ?result "dcOpInfo"))
cgb1 = 1e15*mag(pv("M0" "cgb" ?result "dcOpInfo"))
cds1 = 1e15*mag(pv("M0" "cds" ?result "dcOpInfo"))
cdb1 = 1e15*mag(pv("M0" "cdb" ?result "dcOpInfo"))
vgs1 = mag(pv("M0" "vgs" ?result "dcOpInfo"))
gm1 = pv("M0" "gm" ?result "dcOpInfo")
gds1 = pv("M0" "gds" ?result "dcOpInfo")
id1 = pv("M0" "id" ?result "dcOpInfo")

rds1 = 1/gds1
G1 = gm1*rds1
gm_id1 = gm1/id1
ft1 = gm1/(2*3.1415927*(cgs1+cgd1+cgb1))*1e15/1e6 ;Ft in MHz

cgs2 = 1e15*mag(pv("M1" "cgs" ?result "dcOpInfo"))
cgd2 = 1e15*mag(pv("M1" "cgd" ?result "dcOpInfo"))
cgb2 = 1e15*mag(pv("M1" "cgb" ?result "dcOpInfo"))
cds2 = 1e15*mag(pv("M1" "cds" ?result "dcOpInfo"))
cdb2 = 1e15*mag(pv("M1" "cdb" ?result "dcOpInfo"))
vgs2 = mag(pv("M1" "vgs" ?result "dcOpInfo"))
gm2 = pv("M1" "gm" ?result "dcOpInfo")
gds2 = pv("M1" "gds" ?result "dcOpInfo")
id2 = mag(pv("M1" "id" ?result "dcOpInfo"))

rds2 = 1/gds2
G2 = gm2*rds2
gm_id2 = gm2/id2
ft2 = gm2/(2*3.1415927*(cgs2+cgd2+cgb2))*1e15/1e6 ;Ft in MHz

printf(";NMOS1 parameters:\n L1 = %4.2fu\n W1 = %4.2fu\n NF1 = %d\n IDS1 = %6.5fm\n VDS1 = %4.2f\n VGS1 = %4.5f\n\n" 1e6*L1 1e6*WF1 NF1 1e3*IDS1 VDS1 vgs1)
printf("NMOS1: W1_tot = %4.2fum  L1 = %4.2fum  IDS1 = %6.5fmA  VDS1 = %4.2fV\n" 1e6*(WF1*NF1) 1e6*L1 1e3*IDS1 VDS1)
printf("  gm1 = %5.4fm\n  rds1 = %4.2f\n  cgs1 = %4.2ff\n  cgb1 = %4.2ff\n  cgd1 = %4.2ff\n  cds1 = %4.2ff\n  cdb1 = %4.2ff\n  vgs1 = %5.4f\n  Gain1 = %4.2f\n" 1e3*gm1 rds1 cgs1 cgb1 cgd1 cds1 cdb1 vgs1 G1)
printf("  gm_id1 = %4.2f\n  Ft1 = %4.2f MHz \n\n" gm_id1 ft1)

printf(";PMOS2 parameters:\n L2 = %4.2fu\n W2 = %4.2fu\n NF2 = %d\n IDS2 = %6.5fm\n VDS2 = %4.2f\n VGS2 = %4.5f\n\n" 1e6*L2 1e6*WF2 NF2 1e3*IDS2 VDS2 vgs2)
printf("PMOS2: W1_tot = %4.2fum  L1 = %4.2fum  IDS1 = %6.5fmA  VDS1 = %4.2fV\n" 1e6*(WF2*NF2) 1e6*L2 1e3*IDS2 VDS2)
printf("  gm4 = %5.4fm\n  rds4 = %4.2f\n  cgs4 = %4.2ff\n  cgb4 = %4.2ff\n  cgd4 = %4.2ff\n  cds4 = %4.2ff\n  cdb4 = %4.2ff\n  vgs4 = %5.4f\n  Gain4 = %4.2f\n" 1e3*gm2 rds2 cgs2 cgb2 cgd2 cds2 cdb2 vgs2 G2)
printf("  gm_id4 = %4.2f\n  Ft4 = %4.2f MHz \n\n" gm_id2 ft2)
