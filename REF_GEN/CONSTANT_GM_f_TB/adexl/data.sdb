ADE simulation setup
Run mode: Single Run, Sweeps and Corners
Tests:
  BANDGAP:CONSTANT_GM_TB:1: BANDGAP/CONSTANT_GM_TB/schematic, simulator spectre
    Outputs: i("/R0/PLUS" ?result "dcOp"); i("/V1/PLUS" ?result "dcOp")
  START_UP (off): BANDGAP/CONSTANT_GM_TB/schematic, simulator spectre
Global variables:
  VDD = 1.2
  VDD_PULSE = 0
  EN = 1.2
  EN_PULSE = 0
Corners (all switched off):
  model folders: /opt/pdk/lf11/PDK_LF11ISi_V1_3_2/analog/models/spectre
  MOS_RES (off): temperature=-40 85; lf11is.scs[1v2hvt_ff 1v2hvt_fs 1v2hvt_sf 1v2hvt_ss, res_max res_min]
  RES (off): lf11is.scs[1v2hvt_tt, res_max res_min]
  MOS (off): lf11is.scs[1v2hvt_ff 1v2hvt_fs 1v2hvt_sf 1v2hvt_ss, res_typ]
  C0 (off): lf11is.scs[1v2hvt_tt, res_typ, bjt_typ, mim_typ, dio_typ]
  C1: temperature=-40 85; lf11is.scs[1v2hvt_ff, res_min, bjt_fast, mim_min, dio_fast]
  C2: temperature=-40 85; lf11is.scs[1v2hvt_ss, res_max, bjt_slow, mim_max, dio_slow]
  C3: temperature=-40 85; lf11is.scs[1v2hvt_ss, res_max, bjt_slow, mim_min, dio_slow]
  C4: temperature=-40 85; lf11is.scs[1v2hvt_ff, res_min, bjt_fast, mim_max, dio_fast]
  C5: temperature=-40 85; lf11is.scs[1v2hvt_fs, res_max, bjt_slow, mim_max, dio_fast]
  C6: temperature=-40 85; lf11is.scs[1v2hvt_sf, res_min, bjt_fast, mim_min, dio_slow]
  C7: temperature=-40 85; lf11is.scs[1v2hvt_sf, res_max, bjt_slow, mim_max, dio_fast]
  C8: temperature=-40 85; lf11is.scs[1v2hvt_fs, res_min, bjt_fast, mim_min, dio_slow]
