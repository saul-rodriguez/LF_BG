ADE simulation setup
Test REF_GEN_CONSTANT_GM_f_TB_1: REF_GEN/CONSTANT_GM_f_TB/config, simulator spectre
  Models: /opt/pdk/lf11/PDK_LF11ISi_V1_3_2/analog/models/spectre/lf11is.scs[1v2hvt_tt, 3v3rvt_tt, res_typ, bjt_typ, dio_typ, mim_typ, cvnm2m3_typ, cvnm2m4_typ, nvar1v2hvt_typ, nvar3v3rvt_typ]
  Variables: EN = 0; EN_PULSE = 1.2; VDD = 1.2; VDD_PULSE = 0
  Temperature: 27
  Simulator options: additionalArgs=inlinesubcktcurrent=subckt
  Analysis dc: (saves the operating point)
  Analysis tran: stop=200m
  Signals: /R0/PLUS (terminal), /net6, /EN
