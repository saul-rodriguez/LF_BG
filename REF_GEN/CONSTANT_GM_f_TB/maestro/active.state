ADE simulation setup
Test REF_GEN_CONSTANT_GM_f_TB_1: REF_GEN/CONSTANT_GM_f_TB/schematic, simulator spectre
  Models: /opt/pdk/lf11/PDK_LF11ISi_V1_3_2/analog/models/spectre/lf11is.scs[1v2hvt_tt, 3v3rvt_tt, res_typ, bjt_typ, dio_typ, mim_typ, cvnm2m3_typ, cvnm2m4_typ, nvar1v2hvt_typ, nvar3v3rvt_typ]
  Variables: EN = 1.2; EN_PULSE = 0; VDD = 1.2; VDD_PULSE = 0
  Temperature: 27
  Simulator options: additionalArgs=inlinesubcktcurrent=subckt
  Analysis dc: (saves the operating point)
Run mode: Single Run, Sweeps and Corners
Corners (all switched off):
  model folders: /opt/pdk/lf11/PDK_LF11ISi_V1_3_2/analog/models/spectre
  C0: lf11is.scs[1v2hvt_tt, res_typ, bjt_typ, mim_typ, dio_typ]
  C1: lf11is.scs[1v2hvt_ff, res_min, bjt_fast, mim_min, dio_fast]
  C2: lf11is.scs[1v2hvt_ss, res_max, bjt_slow, mim_max, dio_slow]
  C3: lf11is.scs[1v2hvt_ss, res_max, bjt_slow, mim_min, dio_slow]
  C4: lf11is.scs[1v2hvt_ff, res_min, bjt_fast, mim_max, dio_fast]
  C5: lf11is.scs[1v2hvt_fs, res_max, bjt_slow, mim_max, dio_fast]
  C6: lf11is.scs[1v2hvt_sf, res_min, bjt_fast, mim_min, dio_slow]
  C7: lf11is.scs[1v2hvt_sf, res_max, bjt_slow, mim_max, dio_fast]
  C8: lf11is.scs[1v2hvt_fs, res_min, bjt_fast, mim_min, dio_slow]
Setup values for test REF_GEN_CONSTANT_GM_f_TB_1: EN = 0; EN_PULSE = 1.2
