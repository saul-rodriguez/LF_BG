ADE simulation setup
Run mode: Single Run, Sweeps and Corners
Tests:
  REF_GEN_CONSTANT_GM_f_TB_1: REF_GEN/CONSTANT_GM_f_TB/config, simulator spectre
    Variables: EN = 0; EN_PULSE = 1.2; VDD = 1.2; VDD_PULSE = 0
    Outputs: /R0/PLUS; /net6; /EN
Corners (all switched off):
  model folders: /opt/pdk/lf11/PDK_LF11ISi_V1_3_2/analog/models/spectre
  C0: lf11is.scs[1v2hvt_tt, res_typ, bjt_typ, mim_typ, dio_typ]
  C1: lf11is.scs[1v2hvt_ff, res_min, bjt_fast, mim_min, dio_fast]
  C2: lf11is.scs[1v2hvt_ss, res_max, bjt_slow, mim_max, dio_slow]
  C3: lf11is.scs[1v2hvt_ss, res_max, bjt_slow, mim_min, dio_slow]
  C4: lf11is.scs[1v2hvt_ff, res_min, bjt_fast, mim_max, dio_fast]
  C5: lf11is.scs[1v2hvt_fs, res_max, bjt_slow, mim_max, dio_fast]
  C6: lf11is.scs[1v2hvt_sf, res_min, bjt_fast, mim_min, dio_slow]
  C7: lf11is.scs[1v2hvt_sf, res_max, bjt_slow, mim_max, dio_fast]
  C8: lf11is.scs[1v2hvt_fs, res_min, bjt_fast, mim_min, dio_slow]
