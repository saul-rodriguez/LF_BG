ADE simulation setup
Run mode: Single Run, Sweeps and Corners
Tests:
  REF_GEN:3to8DeMuxSel_tb:1: REF_GEN/3to8DeMuxSel_tb/schematic, simulator spectre
    Outputs: D0; D1; D2; D3; D4; D5; D6; D7
Global variables:
  A0 = 1
  A1 = 1
  A2 = 1
  S = 1
