ADE simulation setup
Test BANDGAP:BG_TRIM_4:1: REF_GEN/REF_GEN_f_TB/config, simulator spectre
  Models: /opt/pdk/lf11/PDK_LF11ISi_V1_3_2/analog/models/spectre/lf11is.scs[1v2hvt_tt, 3v3rvt_tt, res_typ, bjt_typ, dio_typ, mim_typ, cvnm2m3_typ, cvnm2m4_typ, nvar1v2hvt_typ, nvar3v3rvt_typ]
  Temperature: 27
  Simulator options: additionalArgs=inlinesubcktcurrent=subckt
Test OP_BG: REF_GEN/REF_GEN_f_TB/config, simulator spectre
  Models: /opt/pdk/lf11/PDK_LF11ISi_V1_3_2/analog/models/spectre/lf11is.scs[1v2hvt_tt, 3v3rvt_tt, res_typ, bjt_typ, dio_typ, mim_typ, cvnm2m3_typ, cvnm2m4_typ, nvar1v2hvt_typ, nvar3v3rvt_typ]
  Variables: TT = 1u; CL2 = 3p; CL = 150f; CONF_LDO_SEL = 0; CONF_LVDS_SEL = 0; CONF_BG_SL_TRIM = 0; CONF_BG_TRIM = 0; CONF_REF_TRIM = 0; VDD = 1.2; VDD_PULSE = 0; EN = 1.2; EN_PULSE = 0
  Temperature: 50C
  Simulator options: additionalArgs=inlinesubcktcurrent=subckt
  Analysis xf: start=0.01 stop=100M dec=30 p=/I8/VREF
  Analysis dc: (saves the operating point)
  Output V1000 = VDC("/V1000")
  Output V550 = VDC("/V550")
  Output I32nA = IDC("/R5/PLUS")
  Output I128nA = IDC("/R8/PLUS")
  Output BangapRef = VDC("/I8/VREF")
  Output V/V /V0; xf dB20(V/V) = db(getData("/V0" ?result "xf"))
  Output PRN_TRIGGER = VDC("/I8/I0/PRN_TRIGGER")
  Output IDC("/I8/I0/VDDA")
  Signals: /V1000, /V550, /R5/PLUS (terminal), /R8/PLUS (terminal), /I8/VREF, /I8/I0/VDDA (terminal), /I8/I0/PRN_TRIGGER
Test OP: REF_GEN/REF_GEN_f_TB/config, simulator spectre
  Models: /opt/pdk/lf11/PDK_LF11ISi_V1_3_2/analog/models/spectre/lf11is.scs[1v2hvt_tt, 3v3rvt_tt, res_typ, bjt_typ, dio_typ, mim_typ, cvnm2m3_typ, cvnm2m4_typ, nvar1v2hvt_typ, nvar3v3rvt_typ]
  Variables: TT = 1u; CL2 = 3p; CL = 150f; CONF_LDO_SEL = 0; CONF_LVDS_SEL = 0; CONF_BG_SL_TRIM = 0; CONF_BG_TRIM = 0; CONF_REF_TRIM = 0; VDD = 1.2; VDD_PULSE = 0; EN = 1.2; EN_PULSE = 0
  Temperature: 50.0
  Simulator options: additionalArgs=inlinesubcktcurrent=subckt
  Analysis dc: (saves the operating point)
  Output V1000 = VDC("/V1000")
  Output V550 = VDC("/V550")
  Output I32nA = IDC("/R5/PLUS")
  Output I128nA = IDC("/R8/PLUS")
  Output BangapRef = VDC("/I8/VREF")
  Output V/V /V0; xf dB20(V/V) = db(getData("/V0" ?result "xf"))
  Output PRN_TRIGGER = VDC("/I8/I0/PRN_TRIGGER")
  Output REF5_dc_current = IDC("/I8/I7/VDDA")
  Output output noise; V / sqrt(Hz) = db(getData("out" ?result "noise"))
  Output total_noise_V = sqrt(totalNoise("noise" 0.01 100000000 nil))
  Output LDO = VDC("/LDO")
  Output LVDS = VDC("/LVDS")
  Signals: /V1000, /V550, /R5/PLUS (terminal), /R8/PLUS (terminal), /I8/VREF, /I8/I0/PRN_TRIGGER, /I8/I7/VDDA (terminal), /LDO, /LVDS
Test TRAN: REF_GEN/REF_GEN_f_TB/config, simulator spectre
  Models: /opt/pdk/lf11/PDK_LF11ISi_V1_3_2/analog/models/spectre/lf11is.scs[1v2hvt_tt, 3v3rvt_tt, res_typ, bjt_typ, dio_typ, mim_typ, cvnm2m3_typ, cvnm2m4_typ, nvar1v2hvt_typ, nvar3v3rvt_typ]
  Variables: TT = 1u; CL2 = 3p; CL = 150f; CONF_LDO_SEL = 0; CONF_LVDS_SEL = 0; CONF_BG_SL_TRIM = 0; CONF_BG_TRIM = 0; CONF_REF_TRIM = 0; VDD = 0; VDD_PULSE = 1.2; EN = 0; EN_PULSE = 1.2
  Temperature: 50.0
  Simulator options: additionalArgs=inlinesubcktcurrent=subckt
  Analysis dc: (saves the operating point)
  Analysis tran: stop=50m errpreset=conservative
  Output V1000 = VDC("/V1000")
  Output V550 = VDC("/V550")
  Output I32nA = IDC("/R5/PLUS")
  Output I128nA = IDC("/R8/PLUS")
  Output BangapRef = VDC("/I8/VREF")
  Signals: /V1000, /V550, /R5/PLUS (terminal), /R8/PLUS (terminal), /EN, /VDD, /PRN, /LDO, /LVDS
Run mode: Single Run, Sweeps and Corners
Global variables:
  CL = 150f
  CL2 = 3p (off)
  CONF_BG_SL_TRIM = 3
  CONF_BG_TRIM = 3
  CONF_REF_TRIM = 3
  CONF_LVDS_SEL = 7
  CONF_LDO_SEL = 0
  PD = 0
  PD_PULSE = 0
  VDD = 1.2 (off)
  VDD_PULSE = 0 (off)
  EN = 1.2 (off)
  EN_PULSE = 0 (off)
  TT = 1u (off)
Corners (all switched off):
  model folders: /opt/pdk/lf11/PDK_LF11ISi_V1_3_2/analog/models/spectre
  MOS_BJT_RES (off): lf11is.scs[1v2hvt_ss 1v2hvt_ff 1v2hvt_fs 1v2hvt_sf, 3v3rvt_tt, res_max res_min, bjt_fast bjt_slow, dio_typ, mim_typ, cvnm2m3_typ, cvnm2m4_typ, nvar1v2hvt_typ, nvar3v3rvt_typ]
  MOS_BJT_RES_TEMP (off): temperature=-40 85; lf11is.scs[1v2hvt_ss 1v2hvt_ff 1v2hvt_fs 1v2hvt_sf, 3v3rvt_tt, res_max res_min, bjt_fast bjt_slow, dio_typ, mim_typ, cvnm2m3_typ, cvnm2m4_typ, nvar1v2hvt_typ, nvar3v3rvt_typ]
  MOS_BJT_RES_CAP_TEMP (off): temperature=-40 85; lf11is.scs[1v2hvt_ss 1v2hvt_ff 1v2hvt_fs 1v2hvt_sf, 3v3rvt_tt, res_max res_min, bjt_fast bjt_slow, dio_typ, mim_max mim_min, cvnm2m3_typ, cvnm2m4_typ, nvar1v2hvt_typ, nvar3v3rvt_typ]
  Jorgen (off): temperature=85; VDD=1.32; lf11is.scs[1v2hvt_ff, 3v3rvt_tt, res_min, bjt_fast, dio_typ, mim_min, cvnm2m3_typ, cvnm2m4_typ, nvar1v2hvt_typ, nvar3v3rvt_typ]
  MOS_RES_TEMP (off): temperature=-40 85; lf11is.scs[1v2hvt_ss 1v2hvt_ff 1v2hvt_fs 1v2hvt_sf, 3v3rvt_tt, res_max res_min, bjt_typ, dio_typ, mim_typ, cvnm2m3_typ, cvnm2m4_typ, nvar1v2hvt_typ, nvar3v3rvt_typ]
  MOS_BJT_RES_VDD (off): VDD=1.08 1.32; lf11is.scs[1v2hvt_ss 1v2hvt_ff 1v2hvt_fs 1v2hvt_sf, 3v3rvt_tt, res_max res_min, bjt_fast bjt_slow, dio_typ, mim_typ, cvnm2m3_typ, cvnm2m4_typ, nvar1v2hvt_typ, nvar3v3rvt_typ]
  MOS (off): lf11is.scs[1v2hvt_ss 1v2hvt_ff 1v2hvt_fs 1v2hvt_sf, 3v3rvt_tt, res_typ, bjt_typ, dio_typ, mim_typ, cvnm2m3_typ, cvnm2m4_typ, nvar1v2hvt_typ, nvar3v3rvt_typ]
  MOS_BJT (off): lf11is.scs[1v2hvt_ss 1v2hvt_ff 1v2hvt_fs 1v2hvt_sf, 3v3rvt_tt, res_typ, bjt_fast bjt_slow, dio_typ, mim_typ, cvnm2m3_typ, cvnm2m4_typ, nvar1v2hvt_typ, nvar3v3rvt_typ]
  C0: VDD=1.2 1.32; lf11is.scs[1v2hvt_tt, res_typ, bjt_typ, mim_typ, dio_typ]
  C1: temperature=-40 50 85; VDD=1.2 1.32; lf11is.scs[1v2hvt_ff, res_min, bjt_fast, mim_min, dio_fast]
  C2: temperature=-40 50 85; VDD=1.2 1.32; lf11is.scs[1v2hvt_ss, res_max, bjt_slow, mim_max, dio_slow]
  C3: temperature=-40 50 85; VDD=1.2 1.32; lf11is.scs[1v2hvt_ss, res_max, bjt_slow, mim_min, dio_slow]
  C4: temperature=-40 50 85; VDD=1.2 1.32; lf11is.scs[1v2hvt_ff, res_min, bjt_fast, mim_max, dio_fast]
  C5: temperature=-40 50 85; VDD=1.2 1.32; lf11is.scs[1v2hvt_fs, res_max, bjt_slow, mim_max, dio_fast]
  C6: temperature=-40 50 85; VDD=1.2 1.32; lf11is.scs[1v2hvt_sf, res_min, bjt_fast, mim_min, dio_slow]
  C7: temperature=-40 50 85; VDD=1.2 1.32; lf11is.scs[1v2hvt_sf, res_max, bjt_slow, mim_max, dio_fast]
  C8: temperature=-40 50 85; VDD=1.2 1.32; lf11is.scs[1v2hvt_fs, res_min, bjt_fast, mim_min, dio_slow]
Disabled tests: BANDGAP:BG_TRIM_4:1, OP_BG, TRAN
