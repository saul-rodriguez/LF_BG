ADE simulation setup
Run mode: Single Run, Sweeps and Corners
Tests:
  OP: REF_GEN/REF_GEN_f_TB/config, simulator spectre
    Variables: TT = 1u; CL2 = 3p; CL = 150f; CONF_LDO_SEL = 0; CONF_LVDS_SEL = 0; CONF_BG_SL_TRIM = 0; CONF_BG_TRIM = 0; CONF_REF_TRIM = 0; VDD = 1.2; VDD_PULSE = 0; EN = 1.2; EN_PULSE = 0
    Outputs: V1000; V550; I32nA; I128nA; BangapRef; PRN_TRIGGER; IDC(""); REF5_dc_current; total_noise_V; LDO; LVDS
  TRAN (off): REF_GEN/REF_GEN_f_TB/config, simulator spectre
    Variables: TT = 1u; CL2 = 3p; CL = 150f; CONF_LDO_SEL = 0; CONF_LVDS_SEL = 0; CONF_BG_SL_TRIM = 0; CONF_BG_TRIM = 0; CONF_REF_TRIM = 0; VDD = 0; VDD_PULSE = 1.2; EN = 0; EN_PULSE = 1.2
    Outputs: V1000; V550; I32nA; I128nA; BangapRef; /EN; /VDD; /I8/I0/PRN_TRIGGER; /I8/I0/PRN; /PRN; /e; /I8/I0/P; /I8/I0/M46/D; StartupRef
  BANDGAP:BG_TRIM_4:1 (off): REF_GEN/REF_GEN_f_TB/config, simulator spectre
  OP_BG (off): REF_GEN/REF_GEN_f_TB/config, simulator spectre
    Variables: TT = 1u; CL2 = 3p; CL = 150f; CONF_LDO_SEL = 0; CONF_LVDS_SEL = 0; CONF_BG_SL_TRIM = 0; CONF_BG_TRIM = 0; CONF_REF_TRIM = 0; VDD = 1.2; VDD_PULSE = 0; EN = 1.2; EN_PULSE = 0
    Outputs: V1000; V550; I32nA; I128nA; BangapRef; PRN_TRIGGER; "/"; "/IDC(\"/I8/I0/VDDA\")"; IDC("/I8/I0/VDDA")
Global variables:
  CL = 150f
  CL2 = 3p (off)
  CONF_BG_SL_TRIM = 3
  CONF_BG_TRIM = 3
  CONF_REF_TRIM = 3
  CONF_LVDS_SEL = 7
  CONF_LDO_SEL = 0
  PD = 0
  PD_PULSE = 0
  VDD = 1.2 (off)
  VDD_PULSE = 0 (off)
  EN = 1.2 (off)
  EN_PULSE = 0 (off)
  TT = 1u (off)
Corners (all switched off):
  model folders: /opt/pdk/lf11/PDK_LF11ISi_V1_3_2/analog/models/spectre
  MOS_BJT_RES (off): lf11is.scs[1v2hvt_ss 1v2hvt_ff 1v2hvt_fs 1v2hvt_sf, 3v3rvt_tt, res_max res_min, bjt_fast bjt_slow, dio_typ, mim_typ, cvnm2m3_typ, cvnm2m4_typ, nvar1v2hvt_typ, nvar3v3rvt_typ]
  MOS_BJT_RES_TEMP (off): temperature=-40 85; lf11is.scs[1v2hvt_ss 1v2hvt_ff 1v2hvt_fs 1v2hvt_sf, 3v3rvt_tt, res_max res_min, bjt_fast bjt_slow, dio_typ, mim_typ, cvnm2m3_typ, cvnm2m4_typ, nvar1v2hvt_typ, nvar3v3rvt_typ]
  MOS_BJT_RES_CAP_TEMP (off): temperature=-40 85; lf11is.scs[1v2hvt_ss 1v2hvt_ff 1v2hvt_fs 1v2hvt_sf, 3v3rvt_tt, res_max res_min, bjt_fast bjt_slow, dio_typ, mim_max mim_min, cvnm2m3_typ, cvnm2m4_typ, nvar1v2hvt_typ, nvar3v3rvt_typ]
  Jorgen (off): temperature=85; VDD=1.32; lf11is.scs[1v2hvt_ff, 3v3rvt_tt, res_min, bjt_fast, dio_typ, mim_min, cvnm2m3_typ, cvnm2m4_typ, nvar1v2hvt_typ, nvar3v3rvt_typ]
  MOS_RES_TEMP (off): temperature=-40 85; lf11is.scs[1v2hvt_ss 1v2hvt_ff 1v2hvt_fs 1v2hvt_sf, 3v3rvt_tt, res_max res_min, bjt_typ, dio_typ, mim_typ, cvnm2m3_typ, cvnm2m4_typ, nvar1v2hvt_typ, nvar3v3rvt_typ]
  MOS_BJT_RES_VDD (off): VDD=1.08 1.32; lf11is.scs[1v2hvt_ss 1v2hvt_ff 1v2hvt_fs 1v2hvt_sf, 3v3rvt_tt, res_max res_min, bjt_fast bjt_slow, dio_typ, mim_typ, cvnm2m3_typ, cvnm2m4_typ, nvar1v2hvt_typ, nvar3v3rvt_typ]
  MOS (off): lf11is.scs[1v2hvt_ss 1v2hvt_ff 1v2hvt_fs 1v2hvt_sf, 3v3rvt_tt, res_typ, bjt_typ, dio_typ, mim_typ, cvnm2m3_typ, cvnm2m4_typ, nvar1v2hvt_typ, nvar3v3rvt_typ]
  MOS_BJT (off): lf11is.scs[1v2hvt_ss 1v2hvt_ff 1v2hvt_fs 1v2hvt_sf, 3v3rvt_tt, res_typ, bjt_fast bjt_slow, dio_typ, mim_typ, cvnm2m3_typ, cvnm2m4_typ, nvar1v2hvt_typ, nvar3v3rvt_typ]
  C0: VDD=1.2 1.32; lf11is.scs[1v2hvt_tt, res_typ, bjt_typ, mim_typ, dio_typ]
  C1: temperature=-40 50 85; VDD=1.2 1.32; lf11is.scs[1v2hvt_ff, res_min, bjt_fast, mim_min, dio_fast]
  C2: temperature=-40 50 85; VDD=1.2 1.32; lf11is.scs[1v2hvt_ss, res_max, bjt_slow, mim_max, dio_slow]
  C3: temperature=-40 50 85; VDD=1.2 1.32; lf11is.scs[1v2hvt_ss, res_max, bjt_slow, mim_min, dio_slow]
  C4: temperature=-40 50 85; VDD=1.2 1.32; lf11is.scs[1v2hvt_ff, res_min, bjt_fast, mim_max, dio_fast]
  C5: temperature=-40 50 85; VDD=1.2 1.32; lf11is.scs[1v2hvt_fs, res_max, bjt_slow, mim_max, dio_fast]
  C6: temperature=-40 50 85; VDD=1.2 1.32; lf11is.scs[1v2hvt_sf, res_min, bjt_fast, mim_min, dio_slow]
  C7: temperature=-40 50 85; VDD=1.2 1.32; lf11is.scs[1v2hvt_sf, res_max, bjt_slow, mim_max, dio_fast]
  C8: temperature=-40 50 85; VDD=1.2 1.32; lf11is.scs[1v2hvt_fs, res_min, bjt_fast, mim_min, dio_slow]
