ADE simulation setup
Test OP: REF_GEN/REF_GEN_f_TB/config, simulator spectre
  Models: /opt/pdk/lf11/PDK_LF11ISi_V1_3_2/analog/models/spectre/lf11is.scs[1v2hvt_tt, 3v3rvt_tt, res_typ, bjt_typ, dio_typ, mim_typ, cvnm2m3_typ, cvnm2m4_typ, nvar1v2hvt_typ, nvar3v3rvt_typ]
  Variables: TT = 1u; CL2 = 3p; CL = 150f; CONF_LDO_SEL = 0; CONF_LVDS_SEL = 0; CONF_BG_SL_TRIM = 0; CONF_BG_TRIM = 0; CONF_REF_TRIM = 0; VDD = 1.2; VDD_PULSE = 0; EN = 1.2; EN_PULSE = 0
  Temperature: 50.0
  Simulator options: additionalArgs=inlinesubcktcurrent=subckt
  Analysis dc: (saves the operating point)
  Output V1000 = VDC("/V1000")
  Output V550 = VDC("/V550")
  Output I32nA = IDC("/R5/PLUS")
  Output I128nA = IDC("/R8/PLUS")
  Output BangapRef = VDC("/I8/VREF")
  Output V/V /V0; xf dB20(V/V) = db(getData("/V0" ?result "xf"))
  Output PRN_TRIGGER = VDC("/I8/I0/PRN_TRIGGER")
  Output REF5_dc_current = IDC("/I8/I7/VDDA")
  Output output noise; V / sqrt(Hz) = db(getData("out" ?result "noise"))
  Output total_noise_V = sqrt(totalNoise("noise" 0.01 100000000 nil))
  Output LDO = VDC("/LDO")
  Output LVDS = VDC("/LVDS")
  Signals: /V1000, /V550, /R5/PLUS (terminal), /R8/PLUS (terminal), /I8/VREF, /I8/I0/PRN_TRIGGER, /I8/I7/VDDA (terminal), /LDO, /LVDS
Test TRAN: REF_GEN/REF_GEN_f_TB/config, simulator spectre
  Models: /opt/pdk/lf11/PDK_LF11ISi_V1_3_2/analog/models/spectre/lf11is.scs[1v2hvt_tt, 3v3rvt_tt, res_typ, bjt_typ, dio_typ, mim_typ, cvnm2m3_typ, cvnm2m4_typ, nvar1v2hvt_typ, nvar3v3rvt_typ]
  Variables: TT = 1u; CL2 = 3p; CL = 150f; CONF_LDO_SEL = 0; CONF_LVDS_SEL = 0; CONF_BG_SL_TRIM = 0; CONF_BG_TRIM = 0; CONF_REF_TRIM = 0; VDD = 0; VDD_PULSE = 1.2; EN = 0; EN_PULSE = 1.2
  Temperature: 50.0
  Simulator options: additionalArgs=inlinesubcktcurrent=subckt
  Analysis dc: (saves the operating point)
  Analysis tran: stop=50m errpreset=conservative
  Output V1000 = VDC("/V1000")
  Output V550 = VDC("/V550")
  Output I32nA = IDC("/R5/PLUS")
  Output I128nA = IDC("/R8/PLUS")
  Output BangapRef = VDC("/I8/VREF")
  Signals: /V1000, /V550, /R5/PLUS (terminal), /R8/PLUS (terminal), /EN, /VDD, /PRN, /LDO, /LVDS
Test BANDGAP:BG_TRIM_4:1: REF_GEN/REF_GEN_f_TB/config, simulator spectre
  Models: /opt/pdk/lf11/PDK_LF11ISi_V1_3_2/analog/models/spectre/lf11is.scs[1v2hvt_tt, 3v3rvt_tt, res_typ, bjt_typ, dio_typ, mim_typ, cvnm2m3_typ, cvnm2m4_typ, nvar1v2hvt_typ, nvar3v3rvt_typ]
  Temperature: 27
  Simulator options: additionalArgs=inlinesubcktcurrent=subckt
Test OP_BG: REF_GEN/REF_GEN_f_TB/config, simulator spectre
  Models: /opt/pdk/lf11/PDK_LF11ISi_V1_3_2/analog/models/spectre/lf11is.scs[1v2hvt_tt, 3v3rvt_tt, res_typ, bjt_typ, dio_typ, mim_typ, cvnm2m3_typ, cvnm2m4_typ, nvar1v2hvt_typ, nvar3v3rvt_typ]
  Variables: TT = 1u; CL2 = 3p; CL = 150f; CONF_LDO_SEL = 0; CONF_LVDS_SEL = 0; CONF_BG_SL_TRIM = 0; CONF_BG_TRIM = 0; CONF_REF_TRIM = 0; VDD = 1.2; VDD_PULSE = 0; EN = 1.2; EN_PULSE = 0
  Temperature: 50C
  Simulator options: additionalArgs=inlinesubcktcurrent=subckt
  Analysis dc: (saves the operating point)
  Analysis xf: start=0.01 stop=100M dec=30 p=/I8/VREF
  Output V1000 = VDC("/V1000")
  Output V550 = VDC("/V550")
  Output I32nA = IDC("/R5/PLUS")
  Output I128nA = IDC("/R8/PLUS")
  Output BangapRef = VDC("/I8/VREF")
  Output V/V /V0; xf dB20(V/V) = db(getData("/V0" ?result "xf"))
  Output PRN_TRIGGER = VDC("/I8/I0/PRN_TRIGGER")
  Output IDC("/I8/I0/VDDA")
  Signals: /V1000, /V550, /R5/PLUS (terminal), /R8/PLUS (terminal), /I8/VREF, /I8/I0/VDDA (terminal), /I8/I0/PRN_TRIGGER
